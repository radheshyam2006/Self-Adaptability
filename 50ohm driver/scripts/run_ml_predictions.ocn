; run_ml_predictions.ocn
; Auto-generated Ocean script to verify ML-predicted trim codes
; Generated from: TSMC28nm_DRV_ML_MAR6_LookUP_Table_Mar20_ML Predictions.xlsx
; Resistance is measured in the 200ns-250ns window, so tran stop = 300ns (saves ~40% time)

simulator('spectre)
design("tsmc28_tx_tb" "tx_drv_ML" "schematic_seriliazer_top")
resultsDir("./ml_prediction_results")

envOption('termDirectionMismatch "ignore" 'termMismatch "ignore")
saveOption( ?infoOptions list(list("modelParameter" "models" "rawfile" "" "" "" t) list("element" "inst" "rawfile" "" "" "" t) list("outputParameter" "output" "rawfile" "" "" "" t) list("designParamVals" "parameters" "rawfile" "" "" "" t) list("primitives" "primitives" "rawfile" "" "" "" t) list("subckts" "subckts" "rawfile" "" "" "" t) list("asserts" "assert" "rawfile" "" "" "" nil) list("extremeinfo" "all" "logfile" "" "yes" "" nil) list("allcap" "allcap" "file" "" "" "" nil) list("<Click_To_Add>" "none" "rawfile" "" "" "" nil) ) )
save('i "/xdrv_p/out")

; Open CSV output file
out_file = outfile("ml_prediction_results.csv")
fprintf(out_file "Test_No,Test_Case,Process,Vreg,Temperature,GT_pvtp,GT_pvtn,ML_pvtp,ML_pvtn,Simulated_pup(Ohms),Simulated_pdn(Ohms),Excel_pup,Excel_pdn\n")

; ========== Test Case 1: tt_vdd_temp_0 [TT] (Temp=-40.0, Vreg=0.81) ==========
printf("\n>>> Running Test 1/12: tt_vdd_temp_0 [TT] (Temp=-40.0, Vreg=0.81) <<<\n")
modelFile(
    '("/data/cad/pdk_all/pdk_tsmc/pdk_tsmc_28/PDK/TSMC_new_iPDK/models/spectre/crn28hpcp_2d5_elk_v1d0_2p2_shrink0d9_embedded_usage.scs" "ttmacro_mos_moscap")
    '("/data/cad/pdk_all/pdk_tsmc/pdk_tsmc_28/PDK/TSMC_new_iPDK/models/spectre/crn28hpcp_2d5_elk_v1d0_2p2_shrink0d9_embedded_usage.scs" "tt_res_bip_dio_disres")
)
analysis('dc ?saveOppoint t)
analysis('tran ?stop "300n")
desVar("tem" -40.0)
desVar("vreg" 0.81)
temp(-40.0)
desVar("pvt0" 1)
desVar("pvt1" 1)
desVar("pvt2" 1)
desVar("pvt3" 1)
desVar("pvt4" 1)
desVar("pvt5" 0)
desVar("pvt6" 0)
desVar("pvt7" 0)
desVar("pvt8" 0)
desVar("pvt9" 0)
desVar("pvt10" 0)
desVar("pvt11" 0)
desVar("pvt12" 0)
desVar("pvt13" 0)
desVar("pvtn0" 1)
desVar("pvtn1" 1)
desVar("pvtn2" 1)
desVar("pvtn3" 1)
desVar("pvtn4" 1)
desVar("pvtn5" 0)
desVar("pvtn6" 0)
desVar("pvtn7" 0)
desVar("pvtn8" 0)
desVar("pvtn9" 0)
desVar("pvtn10" 0)
desVar("pvtn11" 0)
desVar("pvtn12" 0)
desVar("pvtn13" 0)

run()
selectResults('tran)

pup_val = average((clip((v("/vdd" ?result "tran") - v("/outn" ?result "tran")) 2e-07 2.5e-07) / clip(i("/xdrv_p/out" ?result "tran") 2e-07 2.5e-07)))
pdn_val = (average((clip(v("/outp" ?result "tran") 2e-07 2.5e-07) / clip(i("/xdrv_p/out" ?result "tran") 2e-07 2.5e-07))) * -1)

fprintf(out_file "1, tt_vdd_temp_0, TT, 0.81, -40.0, 0001-1111, 0001-1111, 1-1111, 1-1111, %f, %f, -49.622129, 49.531058\n" pup_val pdn_val)
printf("  Result: pup=%f, pdn=%f\n" pup_val pdn_val)

; ========== Test Case 2: tt_vdd_temp_1 [TT] (Temp=-39.5, Vreg=0.81) ==========
printf("\n>>> Running Test 2/12: tt_vdd_temp_1 [TT] (Temp=-39.5, Vreg=0.81) <<<\n")
modelFile(
    '("/data/cad/pdk_all/pdk_tsmc/pdk_tsmc_28/PDK/TSMC_new_iPDK/models/spectre/crn28hpcp_2d5_elk_v1d0_2p2_shrink0d9_embedded_usage.scs" "ttmacro_mos_moscap")
    '("/data/cad/pdk_all/pdk_tsmc/pdk_tsmc_28/PDK/TSMC_new_iPDK/models/spectre/crn28hpcp_2d5_elk_v1d0_2p2_shrink0d9_embedded_usage.scs" "tt_res_bip_dio_disres")
)
analysis('dc ?saveOppoint t)
analysis('tran ?stop "300n")
desVar("tem" -39.5)
desVar("vreg" 0.81)
temp(-39.5)
desVar("pvt0" 1)
desVar("pvt1" 1)
desVar("pvt2" 1)
desVar("pvt3" 1)
desVar("pvt4" 1)
desVar("pvt5" 0)
desVar("pvt6" 0)
desVar("pvt7" 0)
desVar("pvt8" 0)
desVar("pvt9" 0)
desVar("pvt10" 0)
desVar("pvt11" 0)
desVar("pvt12" 0)
desVar("pvt13" 0)
desVar("pvtn0" 1)
desVar("pvtn1" 1)
desVar("pvtn2" 1)
desVar("pvtn3" 1)
desVar("pvtn4" 1)
desVar("pvtn5" 0)
desVar("pvtn6" 0)
desVar("pvtn7" 0)
desVar("pvtn8" 0)
desVar("pvtn9" 0)
desVar("pvtn10" 0)
desVar("pvtn11" 0)
desVar("pvtn12" 0)
desVar("pvtn13" 0)

run()
selectResults('tran)

pup_val = average((clip((v("/vdd" ?result "tran") - v("/outn" ?result "tran")) 2e-07 2.5e-07) / clip(i("/xdrv_p/out" ?result "tran") 2e-07 2.5e-07)))
pdn_val = (average((clip(v("/outp" ?result "tran") 2e-07 2.5e-07) / clip(i("/xdrv_p/out" ?result "tran") 2e-07 2.5e-07))) * -1)

fprintf(out_file "2, tt_vdd_temp_1, TT, 0.81, -39.5, 0001-1111, 0001-1111, 1-1111, 1-1111, %f, %f, -49.635785, 49.544189\n" pup_val pdn_val)
printf("  Result: pup=%f, pdn=%f\n" pup_val pdn_val)

; ========== Test Case 3: tt_vdd_temp_2662 [TT] (Temp=-29.0, Vreg=0.97) ==========
printf("\n>>> Running Test 3/12: tt_vdd_temp_2662 [TT] (Temp=-29.0, Vreg=0.97) <<<\n")
modelFile(
    '("/data/cad/pdk_all/pdk_tsmc/pdk_tsmc_28/PDK/TSMC_new_iPDK/models/spectre/crn28hpcp_2d5_elk_v1d0_2p2_shrink0d9_embedded_usage.scs" "ttmacro_mos_moscap")
    '("/data/cad/pdk_all/pdk_tsmc/pdk_tsmc_28/PDK/TSMC_new_iPDK/models/spectre/crn28hpcp_2d5_elk_v1d0_2p2_shrink0d9_embedded_usage.scs" "tt_res_bip_dio_disres")
)
analysis('dc ?saveOppoint t)
analysis('tran ?stop "300n")
desVar("tem" -29.0)
desVar("vreg" 0.97)
temp(-29.0)
desVar("pvt0" 1)
desVar("pvt1" 0)
desVar("pvt2" 1)
desVar("pvt3" 1)
desVar("pvt4" 1)
desVar("pvt5" 0)
desVar("pvt6" 0)
desVar("pvt7" 0)
desVar("pvt8" 0)
desVar("pvt9" 0)
desVar("pvt10" 0)
desVar("pvt11" 0)
desVar("pvt12" 0)
desVar("pvt13" 0)
desVar("pvtn0" 0)
desVar("pvtn1" 1)
desVar("pvtn2" 1)
desVar("pvtn3" 1)
desVar("pvtn4" 1)
desVar("pvtn5" 0)
desVar("pvtn6" 0)
desVar("pvtn7" 0)
desVar("pvtn8" 0)
desVar("pvtn9" 0)
desVar("pvtn10" 0)
desVar("pvtn11" 0)
desVar("pvtn12" 0)
desVar("pvtn13" 0)

run()
selectResults('tran)

pup_val = average((clip((v("/vdd" ?result "tran") - v("/outn" ?result "tran")) 2e-07 2.5e-07) / clip(i("/xdrv_p/out" ?result "tran") 2e-07 2.5e-07)))
pdn_val = (average((clip(v("/outp" ?result "tran") 2e-07 2.5e-07) / clip(i("/xdrv_p/out" ?result "tran") 2e-07 2.5e-07))) * -1)

fprintf(out_file "3, tt_vdd_temp_2662, TT, 0.97, -29.0, 1-1101, 1-1110, 1-1101, 1-1110, %f, %f, -48.028266, 48.289339\n" pup_val pdn_val)
printf("  Result: pup=%f, pdn=%f\n" pup_val pdn_val)

; ========== Test Case 4: tt_vdd_temp_10 [TT] (Temp=-35.0, Vreg=0.81) ==========
printf("\n>>> Running Test 4/12: tt_vdd_temp_10 [TT] (Temp=-35.0, Vreg=0.81) <<<\n")
modelFile(
    '("/data/cad/pdk_all/pdk_tsmc/pdk_tsmc_28/PDK/TSMC_new_iPDK/models/spectre/crn28hpcp_2d5_elk_v1d0_2p2_shrink0d9_embedded_usage.scs" "ttmacro_mos_moscap")
    '("/data/cad/pdk_all/pdk_tsmc/pdk_tsmc_28/PDK/TSMC_new_iPDK/models/spectre/crn28hpcp_2d5_elk_v1d0_2p2_shrink0d9_embedded_usage.scs" "tt_res_bip_dio_disres")
)
analysis('dc ?saveOppoint t)
analysis('tran ?stop "300n")
desVar("tem" -35.0)
desVar("vreg" 0.81)
temp(-35.0)
desVar("pvt0" 1)
desVar("pvt1" 1)
desVar("pvt2" 1)
desVar("pvt3" 1)
desVar("pvt4" 1)
desVar("pvt5" 0)
desVar("pvt6" 0)
desVar("pvt7" 0)
desVar("pvt8" 0)
desVar("pvt9" 0)
desVar("pvt10" 0)
desVar("pvt11" 0)
desVar("pvt12" 0)
desVar("pvt13" 0)
desVar("pvtn0" 1)
desVar("pvtn1" 1)
desVar("pvtn2" 1)
desVar("pvtn3" 1)
desVar("pvtn4" 1)
desVar("pvtn5" 0)
desVar("pvtn6" 0)
desVar("pvtn7" 0)
desVar("pvtn8" 0)
desVar("pvtn9" 0)
desVar("pvtn10" 0)
desVar("pvtn11" 0)
desVar("pvtn12" 0)
desVar("pvtn13" 0)

run()
selectResults('tran)

pup_val = average((clip((v("/vdd" ?result "tran") - v("/outn" ?result "tran")) 2e-07 2.5e-07) / clip(i("/xdrv_p/out" ?result "tran") 2e-07 2.5e-07)))
pdn_val = (average((clip(v("/outp" ?result "tran") 2e-07 2.5e-07) / clip(i("/xdrv_p/out" ?result "tran") 2e-07 2.5e-07))) * -1)

fprintf(out_file "4, tt_vdd_temp_10, TT, 0.81, -35.0, 0001-1111, 0001-1111, 1-1111, 1-1111, %f, %f, -49.758893, 49.662062\n" pup_val pdn_val)
printf("  Result: pup=%f, pdn=%f\n" pup_val pdn_val)

; ========== Test Case 5: tt_vdd_temp_3295 [TT] (Temp=123.0, Vreg=0.99) ==========
printf("\n>>> Running Test 5/12: tt_vdd_temp_3295 [TT] (Temp=123.0, Vreg=0.99) <<<\n")
modelFile(
    '("/data/cad/pdk_all/pdk_tsmc/pdk_tsmc_28/PDK/TSMC_new_iPDK/models/spectre/crn28hpcp_2d5_elk_v1d0_2p2_shrink0d9_embedded_usage.scs" "ttmacro_mos_moscap")
    '("/data/cad/pdk_all/pdk_tsmc/pdk_tsmc_28/PDK/TSMC_new_iPDK/models/spectre/crn28hpcp_2d5_elk_v1d0_2p2_shrink0d9_embedded_usage.scs" "tt_res_bip_dio_disres")
)
analysis('dc ?saveOppoint t)
analysis('tran ?stop "300n")
desVar("tem" 123.0)
desVar("vreg" 0.99)
temp(123.0)
desVar("pvt0" 1)
desVar("pvt1" 0)
desVar("pvt2" 1)
desVar("pvt3" 1)
desVar("pvt4" 1)
desVar("pvt5" 1)
desVar("pvt6" 0)
desVar("pvt7" 0)
desVar("pvt8" 0)
desVar("pvt9" 0)
desVar("pvt10" 0)
desVar("pvt11" 0)
desVar("pvt12" 0)
desVar("pvt13" 0)
desVar("pvtn0" 1)
desVar("pvtn1" 1)
desVar("pvtn2" 1)
desVar("pvtn3" 1)
desVar("pvtn4" 1)
desVar("pvtn5" 0)
desVar("pvtn6" 0)
desVar("pvtn7" 0)
desVar("pvtn8" 0)
desVar("pvtn9" 0)
desVar("pvtn10" 0)
desVar("pvtn11" 0)
desVar("pvtn12" 0)
desVar("pvtn13" 0)

run()
selectResults('tran)

pup_val = average((clip((v("/vdd" ?result "tran") - v("/outn" ?result "tran")) 2e-07 2.5e-07) / clip(i("/xdrv_p/out" ?result "tran") 2e-07 2.5e-07)))
pdn_val = (average((clip(v("/outp" ?result "tran") 2e-07 2.5e-07) / clip(i("/xdrv_p/out" ?result "tran") 2e-07 2.5e-07))) * -1)

fprintf(out_file "5, tt_vdd_temp_3295, TT, 0.99, 123.0, 0011-1101, 0011-1100, 11-1101, 1-1111, %f, %f, -52.353791, 51.646073\n" pup_val pdn_val)
printf("  Result: pup=%f, pdn=%f\n" pup_val pdn_val)

; ========== Test Case 6: ss_vdd_temp_1 [SS] (Temp=-39.5, Vreg=0.81) ==========
printf("\n>>> Running Test 6/12: ss_vdd_temp_1 [SS] (Temp=-39.5, Vreg=0.81) <<<\n")
modelFile(
    '("/data/cad/pdk_all/pdk_tsmc/pdk_tsmc_28/PDK/TSMC_new_iPDK/models/spectre/crn28hpcp_2d5_elk_v1d0_2p2_shrink0d9_embedded_usage.scs" "ssmacro_mos_moscap")
    '("/data/cad/pdk_all/pdk_tsmc/pdk_tsmc_28/PDK/TSMC_new_iPDK/models/spectre/crn28hpcp_2d5_elk_v1d0_2p2_shrink0d9_embedded_usage.scs" "ss_res_bip_dio_disres")
)
analysis('dc ?saveOppoint t)
analysis('tran ?stop "300n")
desVar("tem" -39.5)
desVar("vreg" 0.81)
temp(-39.5)
desVar("pvt0" 1)
desVar("pvt1" 0)
desVar("pvt2" 0)
desVar("pvt3" 1)
desVar("pvt4" 1)
desVar("pvt5" 1)
desVar("pvt6" 1)
desVar("pvt7" 1)
desVar("pvt8" 0)
desVar("pvt9" 0)
desVar("pvt10" 0)
desVar("pvt11" 0)
desVar("pvt12" 0)
desVar("pvt13" 0)
desVar("pvtn0" 0)
desVar("pvtn1" 0)
desVar("pvtn2" 0)
desVar("pvtn3" 1)
desVar("pvtn4" 1)
desVar("pvtn5" 1)
desVar("pvtn6" 1)
desVar("pvtn7" 1)
desVar("pvtn8" 0)
desVar("pvtn9" 0)
desVar("pvtn10" 0)
desVar("pvtn11" 0)
desVar("pvtn12" 0)
desVar("pvtn13" 0)

run()
selectResults('tran)

pup_val = average((clip((v("/vdd" ?result "tran") - v("/outn" ?result "tran")) 2e-07 2.5e-07) / clip(i("/xdrv_p/out" ?result "tran") 2e-07 2.5e-07)))
pdn_val = (average((clip(v("/outp" ?result "tran") 2e-07 2.5e-07) / clip(i("/xdrv_p/out" ?result "tran") 2e-07 2.5e-07))) * -1)

fprintf(out_file "6, ss_vdd_temp_1, SS, 0.81, -39.5, 1111-1001, 1111-1000, 1111-1001, 1111-1000, %f, %f, -57.262283, 56.456236\n" pup_val pdn_val)
printf("  Result: pup=%f, pdn=%f\n" pup_val pdn_val)

; ========== Test Case 7: ss_vdd_temp_78 [SS] (Temp=-1.0, Vreg=0.81) ==========
printf("\n>>> Running Test 7/12: ss_vdd_temp_78 [SS] (Temp=-1.0, Vreg=0.81) <<<\n")
modelFile(
    '("/data/cad/pdk_all/pdk_tsmc/pdk_tsmc_28/PDK/TSMC_new_iPDK/models/spectre/crn28hpcp_2d5_elk_v1d0_2p2_shrink0d9_embedded_usage.scs" "ssmacro_mos_moscap")
    '("/data/cad/pdk_all/pdk_tsmc/pdk_tsmc_28/PDK/TSMC_new_iPDK/models/spectre/crn28hpcp_2d5_elk_v1d0_2p2_shrink0d9_embedded_usage.scs" "ss_res_bip_dio_disres")
)
analysis('dc ?saveOppoint t)
analysis('tran ?stop "300n")
desVar("tem" -1.0)
desVar("vreg" 0.81)
temp(-1.0)
desVar("pvt0" 0)
desVar("pvt1" 1)
desVar("pvt2" 0)
desVar("pvt3" 1)
desVar("pvt4" 1)
desVar("pvt5" 1)
desVar("pvt6" 1)
desVar("pvt7" 1)
desVar("pvt8" 0)
desVar("pvt9" 0)
desVar("pvt10" 0)
desVar("pvt11" 0)
desVar("pvt12" 0)
desVar("pvt13" 0)
desVar("pvtn0" 1)
desVar("pvtn1" 0)
desVar("pvtn2" 0)
desVar("pvtn3" 1)
desVar("pvtn4" 1)
desVar("pvtn5" 1)
desVar("pvtn6" 1)
desVar("pvtn7" 1)
desVar("pvtn8" 0)
desVar("pvtn9" 0)
desVar("pvtn10" 0)
desVar("pvtn11" 0)
desVar("pvtn12" 0)
desVar("pvtn13" 0)

run()
selectResults('tran)

pup_val = average((clip((v("/vdd" ?result "tran") - v("/outn" ?result "tran")) 2e-07 2.5e-07) / clip(i("/xdrv_p/out" ?result "tran") 2e-07 2.5e-07)))
pdn_val = (average((clip(v("/outp" ?result "tran") 2e-07 2.5e-07) / clip(i("/xdrv_p/out" ?result "tran") 2e-07 2.5e-07))) * -1)

fprintf(out_file "7, ss_vdd_temp_78, SS, 0.81, -1.0, 1111-1010, 1111-1001, 1111-1010, 1111-1001, %f, %f, -58.469448, 57.598844\n" pup_val pdn_val)
printf("  Result: pup=%f, pdn=%f\n" pup_val pdn_val)

; ========== Test Case 8: ss_vdd_temp_2392 [SS] (Temp=1.0, Vreg=0.95) ==========
printf("\n>>> Running Test 8/12: ss_vdd_temp_2392 [SS] (Temp=1.0, Vreg=0.95) <<<\n")
modelFile(
    '("/data/cad/pdk_all/pdk_tsmc/pdk_tsmc_28/PDK/TSMC_new_iPDK/models/spectre/crn28hpcp_2d5_elk_v1d0_2p2_shrink0d9_embedded_usage.scs" "ssmacro_mos_moscap")
    '("/data/cad/pdk_all/pdk_tsmc/pdk_tsmc_28/PDK/TSMC_new_iPDK/models/spectre/crn28hpcp_2d5_elk_v1d0_2p2_shrink0d9_embedded_usage.scs" "ss_res_bip_dio_disres")
)
analysis('dc ?saveOppoint t)
analysis('tran ?stop "300n")
desVar("tem" 1.0)
desVar("vreg" 0.95)
temp(1.0)
desVar("pvt0" 1)
desVar("pvt1" 1)
desVar("pvt2" 0)
desVar("pvt3" 0)
desVar("pvt4" 1)
desVar("pvt5" 1)
desVar("pvt6" 1)
desVar("pvt7" 1)
desVar("pvt8" 0)
desVar("pvt9" 0)
desVar("pvt10" 0)
desVar("pvt11" 0)
desVar("pvt12" 0)
desVar("pvt13" 0)
desVar("pvtn0" 1)
desVar("pvtn1" 1)
desVar("pvtn2" 0)
desVar("pvtn3" 0)
desVar("pvtn4" 1)
desVar("pvtn5" 1)
desVar("pvtn6" 1)
desVar("pvtn7" 1)
desVar("pvtn8" 0)
desVar("pvtn9" 0)
desVar("pvtn10" 0)
desVar("pvtn11" 0)
desVar("pvtn12" 0)
desVar("pvtn13" 0)

run()
selectResults('tran)

pup_val = average((clip((v("/vdd" ?result "tran") - v("/outn" ?result "tran")) 2e-07 2.5e-07) / clip(i("/xdrv_p/out" ?result "tran") 2e-07 2.5e-07)))
pdn_val = (average((clip(v("/outp" ?result "tran") 2e-07 2.5e-07) / clip(i("/xdrv_p/out" ?result "tran") 2e-07 2.5e-07))) * -1)

fprintf(out_file "8, ss_vdd_temp_2392, SS, 0.95, 1.0, 1111-0011, 1111-0011, 1111-0011, 1111-0011, %f, %f, -55.788689, 55.70838\n" pup_val pdn_val)
printf("  Result: pup=%f, pdn=%f\n" pup_val pdn_val)

; ========== Test Case 9: ss_vdd_temp_2931 [SS] (Temp=106.0, Vreg=0.97) ==========
printf("\n>>> Running Test 9/12: ss_vdd_temp_2931 [SS] (Temp=106.0, Vreg=0.97) <<<\n")
modelFile(
    '("/data/cad/pdk_all/pdk_tsmc/pdk_tsmc_28/PDK/TSMC_new_iPDK/models/spectre/crn28hpcp_2d5_elk_v1d0_2p2_shrink0d9_embedded_usage.scs" "ssmacro_mos_moscap")
    '("/data/cad/pdk_all/pdk_tsmc/pdk_tsmc_28/PDK/TSMC_new_iPDK/models/spectre/crn28hpcp_2d5_elk_v1d0_2p2_shrink0d9_embedded_usage.scs" "ss_res_bip_dio_disres")
)
analysis('dc ?saveOppoint t)
analysis('tran ?stop "300n")
desVar("tem" 106.0)
desVar("vreg" 0.97)
temp(106.0)
desVar("pvt0" 0)
desVar("pvt1" 1)
desVar("pvt2" 0)
desVar("pvt3" 1)
desVar("pvt4" 1)
desVar("pvt5" 1)
desVar("pvt6" 1)
desVar("pvt7" 1)
desVar("pvt8" 0)
desVar("pvt9" 0)
desVar("pvt10" 0)
desVar("pvt11" 0)
desVar("pvt12" 0)
desVar("pvt13" 0)
desVar("pvtn0" 1)
desVar("pvtn1" 0)
desVar("pvtn2" 0)
desVar("pvtn3" 1)
desVar("pvtn4" 1)
desVar("pvtn5" 1)
desVar("pvtn6" 1)
desVar("pvtn7" 1)
desVar("pvtn8" 0)
desVar("pvtn9" 0)
desVar("pvtn10" 0)
desVar("pvtn11" 0)
desVar("pvtn12" 0)
desVar("pvtn13" 0)

run()
selectResults('tran)

pup_val = average((clip((v("/vdd" ?result "tran") - v("/outn" ?result "tran")) 2e-07 2.5e-07) / clip(i("/xdrv_p/out" ?result "tran") 2e-07 2.5e-07)))
pdn_val = (average((clip(v("/outp" ?result "tran") 2e-07 2.5e-07) / clip(i("/xdrv_p/out" ?result "tran") 2e-07 2.5e-07))) * -1)

fprintf(out_file "9, ss_vdd_temp_2931, SS, 0.97, 106.0, 1111-1010, 1111-1001, 1111-1010, 1111-1001, %f, %f, -58.883844, 58.268126\n" pup_val pdn_val)
printf("  Result: pup=%f, pdn=%f\n" pup_val pdn_val)

; ========== Test Case 10: ff_vdd_temp_copy_0_6 [FF] (Temp=-37.0, Vreg=0.81) ==========
printf("\n>>> Running Test 10/12: ff_vdd_temp_copy_0_6 [FF] (Temp=-37.0, Vreg=0.81) <<<\n")
modelFile(
    '("/data/cad/pdk_all/pdk_tsmc/pdk_tsmc_28/PDK/TSMC_new_iPDK/models/spectre/crn28hpcp_2d5_elk_v1d0_2p2_shrink0d9_embedded_usage.scs" "ffmacro_mos_moscap")
    '("/data/cad/pdk_all/pdk_tsmc/pdk_tsmc_28/PDK/TSMC_new_iPDK/models/spectre/crn28hpcp_2d5_elk_v1d0_2p2_shrink0d9_embedded_usage.scs" "ff_res_bip_dio_disres")
)
analysis('dc ?saveOppoint t)
analysis('tran ?stop "300n")
desVar("tem" -37.0)
desVar("vreg" 0.81)
temp(-37.0)
desVar("pvt0" 1)
desVar("pvt1" 0)
desVar("pvt2" 1)
desVar("pvt3" 1)
desVar("pvt4" 0)
desVar("pvt5" 0)
desVar("pvt6" 0)
desVar("pvt7" 0)
desVar("pvt8" 0)
desVar("pvt9" 0)
desVar("pvt10" 0)
desVar("pvt11" 0)
desVar("pvt12" 0)
desVar("pvt13" 0)
desVar("pvtn0" 1)
desVar("pvtn1" 0)
desVar("pvtn2" 1)
desVar("pvtn3" 1)
desVar("pvtn4" 0)
desVar("pvtn5" 0)
desVar("pvtn6" 0)
desVar("pvtn7" 0)
desVar("pvtn8" 0)
desVar("pvtn9" 0)
desVar("pvtn10" 0)
desVar("pvtn11" 0)
desVar("pvtn12" 0)
desVar("pvtn13" 0)

run()
selectResults('tran)

pup_val = average((clip((v("/vdd" ?result "tran") - v("/outn" ?result "tran")) 2e-07 2.5e-07) / clip(i("/xdrv_p/out" ?result "tran") 2e-07 2.5e-07)))
pdn_val = (average((clip(v("/outp" ?result "tran") 2e-07 2.5e-07) / clip(i("/xdrv_p/out" ?result "tran") 2e-07 2.5e-07))) * -1)

fprintf(out_file "10, ff_vdd_temp_copy_0_6, FF, 0.81, -37.0, 0000-1101, 0000-1101, 0-1101, 0-1101, %f, %f, -42.697163, 42.919576\n" pup_val pdn_val)
printf("  Result: pup=%f, pdn=%f\n" pup_val pdn_val)

; ========== Test Case 11: ff_vdd_temp_copy_0_2209 [FF] (Temp=75.0, Vreg=0.93) ==========
printf("\n>>> Running Test 11/12: ff_vdd_temp_copy_0_2209 [FF] (Temp=75.0, Vreg=0.93) <<<\n")
modelFile(
    '("/data/cad/pdk_all/pdk_tsmc/pdk_tsmc_28/PDK/TSMC_new_iPDK/models/spectre/crn28hpcp_2d5_elk_v1d0_2p2_shrink0d9_embedded_usage.scs" "ffmacro_mos_moscap")
    '("/data/cad/pdk_all/pdk_tsmc/pdk_tsmc_28/PDK/TSMC_new_iPDK/models/spectre/crn28hpcp_2d5_elk_v1d0_2p2_shrink0d9_embedded_usage.scs" "ff_res_bip_dio_disres")
)
analysis('dc ?saveOppoint t)
analysis('tran ?stop "300n")
desVar("tem" 75.0)
desVar("vreg" 0.93)
temp(75.0)
desVar("pvt0" 1)
desVar("pvt1" 1)
desVar("pvt2" 1)
desVar("pvt3" 1)
desVar("pvt4" 0)
desVar("pvt5" 0)
desVar("pvt6" 0)
desVar("pvt7" 0)
desVar("pvt8" 0)
desVar("pvt9" 0)
desVar("pvt10" 0)
desVar("pvt11" 0)
desVar("pvt12" 0)
desVar("pvt13" 0)
desVar("pvtn0" 0)
desVar("pvtn1" 1)
desVar("pvtn2" 1)
desVar("pvtn3" 1)
desVar("pvtn4" 0)
desVar("pvtn5" 0)
desVar("pvtn6" 0)
desVar("pvtn7" 0)
desVar("pvtn8" 0)
desVar("pvtn9" 0)
desVar("pvtn10" 0)
desVar("pvtn11" 0)
desVar("pvtn12" 0)
desVar("pvtn13" 0)

run()
selectResults('tran)

pup_val = average((clip((v("/vdd" ?result "tran") - v("/outn" ?result "tran")) 2e-07 2.5e-07) / clip(i("/xdrv_p/out" ?result "tran") 2e-07 2.5e-07)))
pdn_val = (average((clip(v("/outp" ?result "tran") 2e-07 2.5e-07) / clip(i("/xdrv_p/out" ?result "tran") 2e-07 2.5e-07))) * -1)

fprintf(out_file "11, ff_vdd_temp_copy_0_2209, FF, 0.93, 75.0, 0000-1111, 0000-1110, 0-1111, 0-1110, %f, %f, -44.6986, 44.358021\n" pup_val pdn_val)
printf("  Result: pup=%f, pdn=%f\n" pup_val pdn_val)

; ========== Test Case 12: ff_vdd_temp_copy_0_3042 [FF] (Temp=-4.0, Vreg=0.99) ==========
printf("\n>>> Running Test 12/12: ff_vdd_temp_copy_0_3042 [FF] (Temp=-4.0, Vreg=0.99) <<<\n")
modelFile(
    '("/data/cad/pdk_all/pdk_tsmc/pdk_tsmc_28/PDK/TSMC_new_iPDK/models/spectre/crn28hpcp_2d5_elk_v1d0_2p2_shrink0d9_embedded_usage.scs" "ffmacro_mos_moscap")
    '("/data/cad/pdk_all/pdk_tsmc/pdk_tsmc_28/PDK/TSMC_new_iPDK/models/spectre/crn28hpcp_2d5_elk_v1d0_2p2_shrink0d9_embedded_usage.scs" "ff_res_bip_dio_disres")
)
analysis('dc ?saveOppoint t)
analysis('tran ?stop "300n")
desVar("tem" -4.0)
desVar("vreg" 0.99)
temp(-4.0)
desVar("pvt0" 1)
desVar("pvt1" 0)
desVar("pvt2" 1)
desVar("pvt3" 1)
desVar("pvt4" 0)
desVar("pvt5" 0)
desVar("pvt6" 0)
desVar("pvt7" 0)
desVar("pvt8" 0)
desVar("pvt9" 0)
desVar("pvt10" 0)
desVar("pvt11" 0)
desVar("pvt12" 0)
desVar("pvt13" 0)
desVar("pvtn0" 1)
desVar("pvtn1" 0)
desVar("pvtn2" 1)
desVar("pvtn3" 1)
desVar("pvtn4" 0)
desVar("pvtn5" 0)
desVar("pvtn6" 0)
desVar("pvtn7" 0)
desVar("pvtn8" 0)
desVar("pvtn9" 0)
desVar("pvtn10" 0)
desVar("pvtn11" 0)
desVar("pvtn12" 0)
desVar("pvtn13" 0)

run()
selectResults('tran)

pup_val = average((clip((v("/vdd" ?result "tran") - v("/outn" ?result "tran")) 2e-07 2.5e-07) / clip(i("/xdrv_p/out" ?result "tran") 2e-07 2.5e-07)))
pdn_val = (average((clip(v("/outp" ?result "tran") 2e-07 2.5e-07) / clip(i("/xdrv_p/out" ?result "tran") 2e-07 2.5e-07))) * -1)

fprintf(out_file "12, ff_vdd_temp_copy_0_3042, FF, 0.99, -4.0, 0000-1101, 0000-1101, 0-1101, 0-1101, %f, %f, -42.098536, 42.400225\n" pup_val pdn_val)
printf("  Result: pup=%f, pdn=%f\n" pup_val pdn_val)

close(out_file)
printf("\n==========================================\n")
printf("ALL 12 TEST CASES COMPLETE!\n")
printf("Check ml_prediction_results.csv\n")
printf("==========================================\n")
