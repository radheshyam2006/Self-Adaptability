// Design: tsmc28_tx_tb/tx_drv_ML
simulator lang=spectre
global 0
parameters pvt0=0 pvt1=0 pvt2=0 pvt3=1 pvt4=1 pvt5=1 pvt6=1 pvt7=1 pvt8=0 pvt9=0 pvt10=0 pvt11=0 pvt12=0 pvt13=0 pvtn0=0 pvtn1=0 pvtn2=0 pvtn3=1 pvtn4=1 pvtn5=1 pvtn6=1 pvtn7=1 pvtn8=0 pvtn9=0 pvtn10=0 pvtn11=0 pvtn12=0 pvtn13=0 vreg=0.8100 tem=-40.0
    pvt4=1 pvt5=0 pvt6=0 pvt7=0 pvt8=0 pvt9=0 pvtn10=0 pvtn11=0 pvtn12=0 pvtn13=0 pvtn0=1 pvtn1=0 pvtn2=1 pvtn3=1 pvtn4=0 pvtn5=0 pvtn6=0 pvtn7=0 pvtn8=0 pvtn9=0 vreg=0.99 tem=10
include "/data/cad/pdk_all/pdk_tsmc/pdk_tsmc_28/PDK/TSMC_new_iPDK/models/spectre/crn28hpcp_2d5_elk_v1d0_2p2_shrink0d9_embedded_usage.scs" section=ffmacro_mos_moscap
include "/data/cad/pdk_all/pdk_tsmc/pdk_tsmc_28/PDK/TSMC_new_iPDK/models/spectre/crn28hpcp_2d5_elk_v1d0_2p2_shrink0d9_embedded_usage.scs" section=ff_res_bip_dio_disres

// tsmc28_tx/tx_ser_inv_lvt_2x/schematic
subckt tx_ser_inv_lvt_2x gnd ina outa vdd
    M1 (outa ina gnd gnd) nch_mac l=40n w=1u multi=2 nf=2
    M0 (outa ina vdd vdd) pch_mac l=40n w=1.16u multi=2 nf=2
ends tx_ser_inv_lvt_2x

// tsmc28_tx/tx_clkbuf_tri_4x/schematic
subckt tx_clkbuf_tri_4x din dn_out gnd nctrl\<2\> nctrl\<1\> nctrl\<0\> pctrl\<2\> pctrl\<1\> pctrl\<0\> vdd
    M7 (net10 nctrl\<0\> gnd gnd) nch_lvt_mac l=30n w=1u multi=1 nf=2
    M3 (dn_out din net10 gnd) nch_lvt_mac l=30n w=1u multi=4 nf=2
    M6 (net10 nctrl\<2\> gnd gnd) nch_lvt_mac l=30n w=1u multi=2 nf=2
    M1 (net10 nctrl\<1\> gnd gnd) nch_lvt_mac l=30n w=1u multi=2 nf=2
    M2 (net05 pctrl\<2\> vdd vdd) pch_lvt_mac l=30n w=1.16u multi=2 nf=2
    M0 (dn_out din net05 vdd) pch_lvt_mac l=30n w=1.16u multi=4 nf=2
    M5 (net05 pctrl\<0\> vdd vdd) pch_lvt_mac l=30n w=1.16u multi=1 nf=2
    M4 (net05 pctrl\<1\> vdd vdd) pch_lvt_mac l=30n w=1.16u multi=2 nf=2
ends tx_clkbuf_tri_4x

// tsmc28_tx/tx_drv_inv_lvt_8x/schematic
subckt tx_drv_inv_lvt_8x gnd ina outa vdd
    M0 (outa ina vdd vdd) pch_lvt_mac l=30n w=580.0n multi=8 nf=2
    M1 (outa ina gnd gnd) nch_lvt_mac l=30n w=500n multi=8 nf=2
ends tx_drv_inv_lvt_8x

// tsmc28_tx/tx_drv_clk_buffer/schematic
subckt tx_drv_clk_buffer gnd i_clk i_clkb nctrl\<2\> nctrl\<1\> nctrl\<0\> o_clk o_clkb pctrl\<2\> pctrl\<1\> pctrl\<0\> vdd
    I8 (i_clkb net12 gnd nctrl\<2\> nctrl\<1\> nctrl\<0\> pctrl\<2\> pctrl\<1\> pctrl\<0\> vdd) tx_clkbuf_tri_4x
    I9 (i_clk net7 gnd nctrl\<2\> nctrl\<1\> nctrl\<0\> pctrl\<2\> pctrl\<1\> pctrl\<0\> vdd) tx_clkbuf_tri_4x
    I7\<2\> (gnd net8 o_clkb vdd) tx_drv_inv_lvt_8x
    I7\<1\> (gnd net8 o_clkb vdd) tx_drv_inv_lvt_8x
    I7\<0\> (gnd net8 o_clkb vdd) tx_drv_inv_lvt_8x
    I6\<2\> (gnd net9 o_clk vdd) tx_drv_inv_lvt_8x
    I6\<1\> (gnd net9 o_clk vdd) tx_drv_inv_lvt_8x
    I6\<0\> (gnd net9 o_clk vdd) tx_drv_inv_lvt_8x
    I5 (gnd net7 net8 vdd) tx_drv_inv_lvt_8x
    I4 (gnd net12 net9 vdd) tx_drv_inv_lvt_8x
ends tx_drv_clk_buffer

// tsmc28_tx/tx_drv_tristate_lvt_inv_2x/schematic
subckt tx_drv_tristate_lvt_inv_2x din dn_out en enb gnd vdd
    M3 (dn_out din net10 gnd) nch_lvt_mac l=30n w=1u multi=2 nf=2
    M1 (net10 en gnd gnd) nch_lvt_mac l=30n w=1u multi=4 nf=2
    M0 (dn_out din net05 vdd) pch_lvt_mac l=30n w=1.16u multi=2 nf=2
    M4 (net05 enb vdd vdd) pch_lvt_mac l=30n w=1.16u multi=4 nf=2
ends tx_drv_tristate_lvt_inv_2x

// tsmc28_tx/tx_drv_inv_lvt_4x/schematic
subckt tx_drv_inv_lvt_4x gnd ina outa vdd
    M0 (outa ina vdd vdd) pch_lvt_mac l=30n w=580.0n multi=4 nf=2
    M1 (outa ina gnd gnd) nch_lvt_mac l=30n w=500n multi=4 nf=2
ends tx_drv_inv_lvt_4x

// tsmc28_tx/tx_drv_nor/schematic
subckt tx_drv_nor gnd ina inb out vdd
    M5 (net03 ina vdd vdd) pch_mac l=30n w=580.0n multi=1 nf=2
    M4 (net04 inb vdd vdd) pch_mac l=30n w=580.0n multi=1 nf=2
    M0 (out inb net03 vdd) pch_mac l=30n w=580.0n multi=1 nf=2
    PM0 (out ina net04 vdd) pch_mac l=30n w=580.0n multi=1 nf=2
    M3 (out ina gnd gnd) nch_mac l=30n w=500n multi=1 nf=2
    NM0 (out inb gnd gnd) nch_mac l=30n w=500n multi=1 nf=2
ends tx_drv_nor

// tsmc28_tx/tx_drv_nand/schematic
subckt tx_drv_nand gnd ina inb out vdd
    M0 (out inb vdd vdd) pch_mac l=30n w=580.0n multi=1 nf=2
    PM0 (out ina vdd vdd) pch_mac l=30n w=580.0n multi=1 nf=2
    M2 (net06 inb gnd gnd) nch_mac l=30n w=500n multi=1 nf=2
    M3 (out ina net06 gnd) nch_mac l=30n w=500n multi=1 nf=2
    NM0 (out inb net04 gnd) nch_mac l=30n w=500n multi=1 nf=2
    M1 (net04 ina gnd gnd) nch_mac l=30n w=500n multi=1 nf=2
ends tx_drv_nand

// tsmc28_tx/tx_drv_pre_main_mux/schematic
subckt tx_drv_pre_main_mux gnd i_pvtn i_pvtp i_sel main_even main_odd o_data_even o_data_odd pre_even pre_odd turn_on_npvt turn_on_ppvt vdd
    I5 (main_odd net011 main_selb main_sel gnd vdd) tx_drv_tristate_lvt_inv_2x
    I3 (pre_odd net011 pre_selb pre_sel gnd vdd) tx_drv_tristate_lvt_inv_2x
    I1 (pre_even net8 pre_selb pre_sel gnd vdd) tx_drv_tristate_lvt_inv_2x
    I0 (main_even net8 main_selb main_sel gnd vdd) tx_drv_tristate_lvt_inv_2x
    M0 (net011 turn_on vdd vdd) pch_lvt_mac l=30n w=1.16u multi=4 nf=2
    M4 (net8 turn_on vdd vdd) pch_lvt_mac l=30n w=1.16u multi=4 nf=2
    I17 (gnd pre_selb pre_sel vdd) tx_drv_inv_lvt_4x
    I15 (gnd main_selb main_sel vdd) tx_drv_inv_lvt_4x
    I13 (gnd turn_on_ppvt_i turn_on_ppvt vdd) tx_drv_inv_lvt_4x
    I12 (gnd turn_off_ppvt turn_on_ppvt_i vdd) tx_drv_inv_lvt_4x
    I10 (gnd turn_off_npvt turn_on_npvt vdd) tx_drv_inv_lvt_4x
    I8 (gnd turn_off turn_on vdd) tx_drv_inv_lvt_4x
    I6 (gnd i_sel i_selenb vdd) tx_drv_inv_lvt_4x
    I4 (gnd net011 o_data_odd vdd) tx_drv_inv_lvt_4x
    I2 (gnd net8 o_data_even vdd) tx_drv_inv_lvt_4x
    I16 (gnd turn_off i_selenb pre_selb vdd) tx_drv_nor
    I14 (gnd turn_off i_sel main_selb vdd) tx_drv_nor
    I7 (gnd i_pvtp i_pvtn turn_off vdd) tx_drv_nor
    I11 (gnd turn_on i_pvtp turn_off_ppvt vdd) tx_drv_nand
    I9 (gnd turn_on i_pvtn turn_off_npvt vdd) tx_drv_nand
ends tx_drv_pre_main_mux

// tsmc28_tx/tx_maindrv_tristate_lvt_inv_4x/schematic
subckt tx_maindrv_tristate_lvt_inv_4x din dn_out en enb gnd vdd
    M3 (dn_out din net10 gnd) nch_lvt_mac l=30n w=1u multi=4 nf=2
    M1 (net10 en gnd gnd) nch_lvt_mac l=30n w=1u multi=4 nf=2
    M0 (dn_out din net05 vdd) pch_lvt_mac l=30n w=1.16u multi=4 nf=2
    M4 (net05 enb vdd vdd) pch_lvt_mac l=30n w=1.16u multi=4 nf=2
ends tx_maindrv_tristate_lvt_inv_4x

// tsmc28_tx/tx_drv_2to1_mux/schematic
subckt tx_drv_2to1_mux Even_data Odd_data clk clkb gnd out vdd
    I1 (Odd_data out clkb clk gnd vdd) tx_maindrv_tristate_lvt_inv_4x
    I0 (Even_data out clk clkb gnd vdd) tx_maindrv_tristate_lvt_inv_4x
ends tx_drv_2to1_mux

// tsmc28_tx/tx_drv_main_4x/schematic
subckt tx_drv_main_4x din en enb gnd out vdd
    M0 (net014 enb vdd vdd) pch_lvt_mac l=30n w=580.0n multi=16 nf=2
    M1 (dout din net014 vdd) pch_lvt_mac l=30n w=580.0n multi=8 nf=2
    M2 (net015 en gnd gnd) nch_lvt_mac l=30n w=560.0n multi=8 nf=2
    M3 (dout din net015 gnd) nch_lvt_mac l=30n w=560.0n multi=16 nf=2
R3 (dout out gnd ) rupolym_m lr=3.2u wr=1.2u multi=(4) m=1

ends tx_drv_main_4x

// tsmc28_tx/tx_predrv_inv4x/schematic
subckt tx_predrv_inv4x din dn_out gnd nctrl\<2\> nctrl\<1\> nctrl\<0\> pctrl\<2\> pctrl\<1\> pctrl\<0\> vdd
    M7 (net10 nctrl\<0\> gnd gnd) nch_lvt_mac l=30n w=1u multi=1 nf=2
    M3 (dn_out din net10 gnd) nch_lvt_mac l=30n w=1u multi=4 nf=2
    M6 (net10 nctrl\<2\> gnd gnd) nch_lvt_mac l=30n w=1u multi=2 nf=2
    M1 (net10 nctrl\<1\> gnd gnd) nch_lvt_mac l=30n w=1u multi=2 nf=2
    M2 (net05 pctrl\<2\> vdd vdd) pch_lvt_mac l=30n w=1.16u multi=2 nf=2
    M0 (dn_out din net05 vdd) pch_lvt_mac l=30n w=1.16u multi=4 nf=2
    M5 (net05 pctrl\<0\> vdd vdd) pch_lvt_mac l=30n w=1.16u multi=1 nf=2
    M4 (net05 pctrl\<1\> vdd vdd) pch_lvt_mac l=30n w=1.16u multi=2 nf=2
ends tx_predrv_inv4x

// tsmc28_tx/tx_drv_leg_4x/schematic
subckt tx_drv_leg_4x clk clkb gnd i_pvtn i_pvtp i_sel main_even main_odd nctrl\<2\> nctrl\<1\> nctrl\<0\> out pctrl\<2\> pctrl\<1\> pctrl\<0\> pre_even pre_odd vdd
    I0 (gnd i_pvtn i_pvtp i_sel main_even main_odd even_d odd_d pre_even pre_odd turn_on_npvt turn_on_ppvt vdd) tx_drv_pre_main_mux
    Idrvmux (even_d odd_d clkb clk gnd dinb vdd) tx_drv_2to1_mux
    I1 (din turn_on_npvt turn_on_ppvt gnd out vdd) tx_drv_main_4x
    I2 (dinb din gnd nctrl\<2\> nctrl\<1\> nctrl\<0\> pctrl\<2\> pctrl\<1\> pctrl\<0\> vdd) tx_predrv_inv4x
ends tx_drv_leg_4x

// tsmc28_tx/tx_drv_main_1x/schematic
subckt tx_drv_main_1x din en enb gnd out vdd
    M3 (dout din net015 gnd) nch_lvt_mac l=30n w=560.0n multi=2 nf=2
    M2 (net015 en gnd gnd) nch_lvt_mac l=30n w=560.0n multi=4 nf=2
R3 (dout out gnd ) rupolym_m lr=3.2u wr=1.2u multi=(1) m=1

    M0 (net014 enb vdd vdd) pch_lvt_mac l=30n w=580.0n multi=4 nf=2
    M1 (dout din net014 vdd) pch_lvt_mac l=30n w=580.0n multi=2 nf=2
ends tx_drv_main_1x

// tsmc28_tx/tx_predrv_inv2x/schematic
subckt tx_predrv_inv2x din dn_out gnd nctrl\<2\> nctrl\<1\> nctrl\<0\> pctrl\<2\> pctrl\<1\> pctrl\<0\> vdd
    M7 (net10 nctrl\<0\> gnd gnd) nch_lvt_mac l=30n w=1u multi=1 nf=2
    M3 (dn_out din net10 gnd) nch_lvt_mac l=30n w=1u multi=2 nf=2
    M6 (net10 nctrl\<2\> gnd gnd) nch_lvt_mac l=30n w=1u multi=1 nf=2
    M1 (net10 nctrl\<1\> gnd gnd) nch_lvt_mac l=30n w=1u multi=1 nf=2
    M2 (net05 pctrl\<2\> vdd vdd) pch_lvt_mac l=30n w=1.16u multi=1 nf=2
    M0 (dn_out din net05 vdd) pch_lvt_mac l=30n w=1.16u multi=2 nf=2
    M5 (net05 pctrl\<0\> vdd vdd) pch_lvt_mac l=30n w=1.16u multi=1 nf=2
    M4 (net05 pctrl\<1\> vdd vdd) pch_lvt_mac l=30n w=1.16u multi=1 nf=2
ends tx_predrv_inv2x

// tsmc28_tx/tx_drv_leg_1x/schematic
subckt tx_drv_leg_1x clk clkb gnd i_pvtn i_pvtp i_sel main_even main_odd nctrl\<2\> nctrl\<1\> nctrl\<0\> out pctrl\<2\> pctrl\<1\> pctrl\<0\> pre_even pre_odd vdd
    I0 (gnd i_pvtn i_pvtp i_sel main_even main_odd net11 net12 pre_even pre_odd turn_on_npvt turn_on_ppvt vdd) tx_drv_pre_main_mux
    Idrvmux (net11 net12 clkb clk gnd dinb vdd) tx_drv_2to1_mux
    I1 (din turn_on_npvt turn_on_ppvt gnd out vdd) tx_drv_main_1x
    I2 (dinb din gnd nctrl\<2\> nctrl\<1\> nctrl\<0\> pctrl\<2\> pctrl\<1\> pctrl\<0\> vdd) tx_predrv_inv2x
ends tx_drv_leg_1x

// tsmc28_tx/tx_drv_main_2x/schematic
subckt tx_drv_main_2x din en enb gnd out vdd
    M0 (net014 enb vdd vdd) pch_lvt_mac l=30n w=580.0n multi=8 nf=2
    M1 (dout din net014 vdd) pch_lvt_mac l=30n w=580.0n multi=4 nf=2
    M2 (net015 en gnd gnd) nch_lvt_mac l=30n w=560.0n multi=6 nf=2
    M3 (dout din net015 gnd) nch_lvt_mac l=30n w=560.0n multi=8 nf=2
R3 (dout out gnd ) rupolym_m lr=3.4u wr=1.28u multi=(2) m=1

ends tx_drv_main_2x

// tsmc28_tx/tx_drv_leg_2x/schematic
subckt tx_drv_leg_2x clk clkb gnd i_pvtn i_pvtp i_sel main_even main_odd nctrl\<2\> nctrl\<1\> nctrl\<0\> out pctrl\<2\> pctrl\<1\> pctrl\<0\> pre_even pre_odd vdd
    I0 (gnd i_pvtn i_pvtp i_sel main_even main_odd even_data odd_data pre_even pre_odd turn_on_npvt turn_on_ppvt vdd) tx_drv_pre_main_mux
    Idrvmux (even_data odd_data clkb clk gnd dinb vdd) tx_drv_2to1_mux
    I1 (din turn_on_npvt turn_on_ppvt gnd out vdd) tx_drv_main_2x
    I2 (dinb din gnd nctrl\<2\> nctrl\<1\> nctrl\<0\> pctrl\<2\> pctrl\<1\> pctrl\<0\> vdd) tx_predrv_inv2x
ends tx_drv_leg_2x

// tsmc28_tx/tx_drv_top/schematic
subckt tx_drv_top gnd i_clk i_clkb i_mainsel\<6\> i_mainsel\<5\> i_mainsel\<4\> i_mainsel\<3\> i_mainsel\<2\> i_mainsel\<1\> i_mainsel\<0\> i_postsel2\<2\> i_postsel2\<1\> i_postsel2\<0\> i_postsel\<6\> i_postsel\<5\> i_postsel\<4\> i_postsel\<3\> i_postsel\<2\> i_postsel\<1\> i_postsel\<0\> i_presel\<5\> i_presel\<4\> i_presel\<3\> i_presel\<2\> i_presel\<1\> i_presel\<0\> i_pvtn\<13\> i_pvtn\<12\> i_pvtn\<11\> i_pvtn\<10\> i_pvtn\<9\> i_pvtn\<8\> i_pvtn\<7\> i_pvtn\<6\> i_pvtn\<5\> i_pvtn\<4\> i_pvtn\<3\> i_pvtn\<2\> i_pvtn\<1\> i_pvtn\<0\> i_pvtp\<13\> i_pvtp\<12\> i_pvtp\<11\> i_pvtp\<10\> i_pvtp\<9\> i_pvtp\<8\> i_pvtp\<7\> i_pvtp\<6\> i_pvtp\<5\> i_pvtp\<4\> i_pvtp\<3\> i_pvtp\<2\> i_pvtp\<1\> i_pvtp\<0\> main_even main_even_b main_odd main_odd_b nctrl\<2\> nctrl\<1\> nctrl\<0\> out pctrl\<2\> pctrl\<1\> pctrl\<0\> pd_b post2_even post2_odd post_even post_odd pre_even pre_odd vdd veg_clk
    I0 (gnd i_clk i_clkb nctrl\<2\> nctrl\<1\> nctrl\<0\> o_clk o_clkb pctrl\<2\> pctrl\<1\> pctrl\<0\> veg_clk) tx_drv_clk_buffer
    I22 (o_clk o_clkb gnd i_pvtn\<8\> i_pvtp\<8\> i_postsel2\<2\> main_even main_odd nctrl\<2\> nctrl\<1\> nctrl\<0\> out pctrl\<2\> pctrl\<1\> pctrl\<0\> post2_even post2_odd vdd) tx_drv_leg_4x
    I21 (o_clk o_clkb gnd pd_b pd_b i_postsel2\<2\> main_even main_odd nctrl\<2\> nctrl\<1\> nctrl\<0\> out pctrl\<2\> pctrl\<1\> pctrl\<0\> post2_even post2_odd vdd) tx_drv_leg_4x
    I18 (o_clk o_clkb gnd i_pvtn\<10\> i_pvtp\<10\> i_postsel\<6\> main_even main_odd nctrl\<2\> nctrl\<1\> nctrl\<0\> out pctrl\<2\> pctrl\<1\> pctrl\<0\> post_even post_odd vdd) tx_drv_leg_4x
    I17 (o_clk o_clkb gnd i_pvtn\<7\> i_pvtp\<7\> i_postsel\<5\> main_even main_odd nctrl\<2\> nctrl\<1\> nctrl\<0\> out pctrl\<2\> pctrl\<1\> pctrl\<0\> post_even post_odd vdd) tx_drv_leg_4x
    I16 (o_clk o_clkb gnd i_pvtn\<4\> i_pvtp\<4\> i_postsel\<4\> main_even main_odd nctrl\<2\> nctrl\<1\> nctrl\<0\> out pctrl\<2\> pctrl\<1\> pctrl\<0\> post_even post_odd vdd) tx_drv_leg_4x
    I15 (o_clk o_clkb gnd pd_b pd_b i_postsel\<3\> main_even main_odd nctrl\<2\> nctrl\<1\> nctrl\<0\> out pctrl\<2\> pctrl\<1\> pctrl\<0\> post_even post_odd vdd) tx_drv_leg_4x
    I14 (o_clk o_clkb gnd pd_b pd_b i_postsel\<2\> main_even main_odd nctrl\<2\> nctrl\<1\> nctrl\<0\> out pctrl\<2\> pctrl\<1\> pctrl\<0\> post_even post_odd vdd) tx_drv_leg_4x
    I11 (o_clk o_clkb gnd i_pvtn\<13\> i_pvtp\<13\> i_mainsel\<6\> main_even main_odd nctrl\<2\> nctrl\<1\> nctrl\<0\> out pctrl\<2\> pctrl\<1\> pctrl\<0\> main_even_b main_odd_b vdd) tx_drv_leg_4x
    I10 (o_clk o_clkb gnd i_pvtn\<12\> i_pvtp\<12\> i_mainsel\<5\> main_even main_odd nctrl\<2\> nctrl\<1\> nctrl\<0\> out pctrl\<2\> pctrl\<1\> pctrl\<0\> main_even_b main_odd_b vdd) tx_drv_leg_4x
    I9 (o_clk o_clkb gnd i_pvtn\<11\> i_pvtp\<11\> i_mainsel\<4\> main_even main_odd nctrl\<2\> nctrl\<1\> nctrl\<0\> out pctrl\<2\> pctrl\<1\> pctrl\<0\> main_even_b main_odd_b vdd) tx_drv_leg_4x
    I8 (o_clk o_clkb gnd i_pvtn\<3\> i_pvtp\<3\> i_mainsel\<2\> main_even main_odd nctrl\<2\> nctrl\<1\> nctrl\<0\> out pctrl\<2\> pctrl\<1\> pctrl\<0\> main_even_b main_odd_b vdd) tx_drv_leg_4x
    I5\<2\> (o_clk o_clkb gnd i_pvtn\<2\> i_pvtp\<2\> i_presel\<5\> main_even main_odd nctrl\<2\> nctrl\<1\> nctrl\<0\> out pctrl\<2\> pctrl\<1\> pctrl\<0\> pre_even pre_odd vdd) tx_drv_leg_4x
    I5\<1\> (o_clk o_clkb gnd i_pvtn\<6\> i_pvtp\<6\> i_presel\<4\> main_even main_odd nctrl\<2\> nctrl\<1\> nctrl\<0\> out pctrl\<2\> pctrl\<1\> pctrl\<0\> pre_even pre_odd vdd) tx_drv_leg_4x
    I5\<0\> (o_clk o_clkb gnd i_pvtn\<9\> i_pvtp\<9\> i_presel\<3\> main_even main_odd nctrl\<2\> nctrl\<1\> nctrl\<0\> out pctrl\<2\> pctrl\<1\> pctrl\<0\> pre_even pre_odd vdd) tx_drv_leg_4x
    I4 (o_clk o_clkb gnd pd_b pd_b i_presel\<2\> main_even main_odd nctrl\<2\> nctrl\<1\> nctrl\<0\> out pctrl\<2\> pctrl\<1\> pctrl\<0\> pre_even pre_odd vdd) tx_drv_leg_4x
    I1 (o_clk o_clkb gnd i_pvtn\<5\> i_pvtp\<5\> i_mainsel\<3\> main_even main_odd nctrl\<2\> nctrl\<1\> nctrl\<0\> out pctrl\<2\> pctrl\<1\> pctrl\<0\> main_even_b main_odd_b vdd) tx_drv_leg_4x
    I19 (o_clk o_clkb gnd pd_b pd_b i_postsel2\<0\> main_even main_odd nctrl\<2\> nctrl\<1\> nctrl\<0\> out pctrl\<2\> pctrl\<1\> pctrl\<0\> post2_even post2_odd vdd) tx_drv_leg_1x
    I12 (o_clk o_clkb gnd pd_b pd_b i_postsel\<0\> main_even main_odd nctrl\<2\> nctrl\<1\> nctrl\<0\> out pctrl\<2\> pctrl\<1\> pctrl\<0\> post_even post_odd vdd) tx_drv_leg_1x
    I6 (o_clk o_clkb gnd i_pvtn\<0\> i_pvtp\<0\> i_mainsel\<0\> main_even main_odd nctrl\<2\> nctrl\<1\> nctrl\<0\> out pctrl\<2\> pctrl\<1\> pctrl\<0\> main_even_b main_odd_b vdd) tx_drv_leg_1x
    I2 (o_clk o_clkb gnd pd_b pd_b i_presel\<0\> main_even main_odd nctrl\<2\> nctrl\<1\> nctrl\<0\> out pctrl\<2\> pctrl\<1\> pctrl\<0\> pre_even pre_odd vdd) tx_drv_leg_1x
    I20 (o_clk o_clkb gnd pd_b pd_b i_postsel2\<1\> main_even main_odd nctrl\<2\> nctrl\<1\> nctrl\<0\> out pctrl\<2\> pctrl\<1\> pctrl\<0\> post2_even post2_odd vdd) tx_drv_leg_2x
    I13 (o_clk o_clkb gnd pd_b pd_b i_postsel\<1\> main_even main_odd nctrl\<2\> nctrl\<1\> nctrl\<0\> out pctrl\<2\> pctrl\<1\> pctrl\<0\> post_even post_odd vdd) tx_drv_leg_2x
    I7 (o_clk o_clkb gnd i_pvtn\<1\> i_pvtp\<1\> i_mainsel\<1\> main_even main_odd nctrl\<2\> nctrl\<1\> nctrl\<0\> out pctrl\<2\> pctrl\<1\> pctrl\<0\> main_even_b main_odd_b vdd) tx_drv_leg_2x
    I3 (o_clk o_clkb gnd pd_b pd_b i_presel\<1\> main_even main_odd nctrl\<2\> nctrl\<1\> nctrl\<0\> out pctrl\<2\> pctrl\<1\> pctrl\<0\> pre_even pre_odd vdd) tx_drv_leg_2x
ends tx_drv_top

// tsmc28_tx_tb/tx_drv_ML/schematic_seriliazer_top
C24 (net017 0) capacitor c=100f
C23 (outn 0) capacitor c=100f
C22 (outp 0) capacitor c=100f
C26 (ring_cmos_res gnd) capacitor c=10f
C25 (ring_constnat_gm gnd) capacitor c=10f
C27 (ring_cmos gnd) capacitor c=10f
V38 (pvtp\<5\> 0) vsource dc=vreg*pvt5 type=dc
V37 (pvtp\<4\> 0) vsource dc=vreg*pvt4 type=dc
V36 (pvtp\<3\> 0) vsource dc=vreg*pvt3 type=dc
V35 (pvtp\<0\> 0) vsource dc=vreg*pvt0 type=dc
V34 (pvtp\<1\> 0) vsource dc=vreg*pvt1 type=dc
V33 (pvtp\<2\> 0) vsource dc=vreg*pvt2 type=dc
V32 (pvtp\<8\> 0) vsource dc=vreg*pvt8 type=dc
V31 (pvtp\<7\> 0) vsource dc=vreg*pvt7 type=dc
V30 (pvtp\<6\> 0) vsource dc=vreg*pvt6 type=dc
V29 (pvtp\<9\> 0) vsource dc=vreg*pvt9 type=dc
V28 (pvtp\<10\> 0) vsource dc=vreg*pvt10 type=dc
V27 (pvtp\<11\> 0) vsource dc=vreg*pvt11 type=dc
V26 (pvtp\<12\> 0) vsource dc=vreg*pvt12 type=dc
V25 (pvtp\<13\> 0) vsource dc=vreg*pvt13 type=dc
V24 (vdd1 0) vsource dc=vreg type=dc
V53 (pvtn\<5\> 0) vsource dc=vreg*pvtn5 type=dc
V52 (pvtn\<4\> 0) vsource dc=vreg*pvtn4 type=dc
V51 (pvtn\<3\> 0) vsource dc=vreg*pvtn3 type=dc
V50 (pvtn\<0\> 0) vsource dc=vreg*pvtn0 type=dc
V49 (pvtn\<1\> 0) vsource dc=vreg*pvtn1 type=dc
V48 (pvtn\<2\> 0) vsource dc=vreg*pvtn2 type=dc
V22 (gnd 0) vsource dc=0 type=dc
V47 (pvtn\<8\> 0) vsource dc=vreg*pvtn8 type=dc
V46 (pvtn\<7\> 0) vsource dc=vreg*pvtn7 type=dc
V45 (pvtn\<6\> 0) vsource dc=vreg*pvtn6 type=dc
V44 (pvtn\<9\> 0) vsource dc=vreg*pvtn9 type=dc
V43 (pvtn\<10\> 0) vsource dc=vreg*pvtn10 type=dc
V42 (pvtn\<11\> 0) vsource dc=vreg*pvtn11 type=dc
V41 (pvtn\<12\> 0) vsource dc=vreg*pvtn12 type=dc
V40 (pvtn\<13\> 0) vsource dc=vreg*pvtn13 type=dc
V13 (pd 0) vsource dc=vreg type=pwl wave=[ 0 vreg 3n vreg 3.05n 0 10n 0 ]
V0 (vdd 0) vsource dc=vreg type=pwl wave=[ 0 0 50n vreg ]
I21 (0 pd pdb vdd1) tx_ser_inv_lvt_2x
xdrv_n (gnd vdd gnd gnd gnd gnd gnd gnd gnd gnd gnd gnd gnd gnd gnd gnd gnd gnd gnd gnd gnd gnd gnd gnd gnd gnd pvtp\<13\> pvtp\<12\> pvtp\<11\> pvtp\<10\> pvtp\<9\> pvtp\<8\> pvtp\<7\> pvtp\<6\> pvtp\<5\> pvtp\<4\> pvtp\<3\> pvtp\<2\> pvtp\<1\> pvtp\<0\> pvtn\<13\> pvtn\<12\> pvtn\<11\> pvtn\<10\> pvtn\<9\> pvtn\<8\> pvtn\<7\> pvtn\<6\> pvtn\<5\> pvtn\<4\> pvtn\<3\> pvtn\<2\> pvtn\<1\> pvtn\<0\> vdd gnd gnd vdd net043\<0\> net043\<1\> net043\<2\> outn net044\<0\> net044\<1\> net044\<2\> vdd vdd gnd vdd gnd vdd gnd vdd vdd) tx_drv_top
xdrv_p (gnd vdd gnd gnd gnd gnd gnd gnd gnd gnd gnd gnd gnd gnd gnd gnd gnd gnd gnd gnd gnd gnd gnd gnd gnd gnd pvtp\<13\> pvtp\<12\> pvtp\<11\> pvtp\<10\> pvtp\<9\> pvtp\<8\> pvtp\<7\> pvtp\<6\> pvtp\<5\> pvtp\<4\> pvtp\<3\> pvtp\<2\> pvtp\<1\> pvtp\<0\> pvtn\<13\> pvtn\<12\> pvtn\<11\> pvtn\<10\> pvtn\<9\> pvtn\<8\> pvtn\<7\> pvtn\<6\> pvtn\<5\> pvtn\<4\> pvtn\<3\> pvtn\<2\> pvtn\<1\> pvtn\<0\> vdd gnd vdd gnd net045\<0\> net045\<1\> net045\<2\> outp net046\<0\> net046\<1\> net046\<2\> vdd vdd gnd vdd gnd vdd gnd vdd vdd) tx_drv_top
R1 (net017 outn) resistor r=50
R0 (outp net017) resistor r=50
simulatorOptions options temp=tem
tran tran stop=500n
dcOp dc
save xdrv_p:62
