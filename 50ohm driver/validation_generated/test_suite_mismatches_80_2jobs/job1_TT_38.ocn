; =============================================================================
; CADENCE SPECTRE OCEAN SCRIPT: JOB 1 - TT (MISMATCH VALIDATION)
; Total Test Cases: 38 | PDK Model: 1.8V (crn28hpcp_1d8_elk...)
; Simulating with ML PREDICTED TRIM to verify 48-52 Ohm Spec Compliance
; Results CSV: results_job1_TT.csv | Results Directory: ./ocean_results_bad_job1
; =============================================================================
simulator('spectre)
design("tsmc28_tx_tb" "tx_drv_ML" "schematic_seriliazer_top")
resultsDir("./ocean_results_bad_job1")
analysis('dc ?saveOppoint t)
analysis('tran ?stop "275n")
envOption('termDirectionMismatch "ignore" 'termMismatch "ignore")
saveOption( ?infoOptions list(list("modelParameter" "models" "rawfile" "" "" "" t) list("element" "inst" "rawfile" "" "" "" t) list("outputParameter" "output" "rawfile" "" "" "" t) list("designParamVals" "parameters" "rawfile" "" "" "" t) list("primitives" "primitives" "rawfile" "" "" "" t) list("subckts" "subckts" "rawfile" "" "" "" t) list("asserts" "assert" "rawfile" "" "" "" nil) list("extremeinfo" "all" "logfile" "" "yes" "" nil) list("allcap" "allcap" "file" "" "" "" nil) list("<Click_To_Add>" "none" "rawfile" "" "" "" nil) ) )
save('i "/xdrv_p/out")

out_file = outfile("results_job1_TT.csv")
fprintf(out_file "test_id,corner,vreg,temp,pmon,gt_pvtp,gt_pvtn,ml_pvtp,ml_pvtn,err_p,err_n,sim_pup,sim_pdn,gt_pup,gt_pdn\n")
drain(out_file)

; --- Set PDK Corner Model for TT ---
modelFile(
    '("/data/cad/pdk_all/pdk_tsmc/pdk_tsmc_28/PDK/TSMC_new_iPDK/models/spectre/crn28hpcp_1d8_elk_v1d0_2p2_shrink0d9_embedded_usage.scs" "ttmacro_mos_moscap")
    '("/data/cad/pdk_all/pdk_tsmc/pdk_tsmc_28/PDK/TSMC_new_iPDK/models/spectre/crn28hpcp_1d8_elk_v1d0_2p2_shrink0d9_embedded_usage.scs" "tt_res_bip_dio_disres")
    '("/data/cad/pdk_all/pdk_tsmc/pdk_tsmc_28/PDK/TSMC_new_iPDK/models/spectre/crn28hpcp_1d8_elk_v1d0_2p2_shrink0d9_embedded_usage.scs" "pre_simu")
)

; --- Sim 1/38: [BAD_43] TT, V=0.81V, T=-34.5C | ML=(31,14) vs GT=(31,31) ---
printf("\n>>> [JOB 1: TT] Sim 1/38: BAD_43 (TT) V=0.81V, T=-34.5C | ML=(31,14) GT=(31,31) <<<\n")
desVar("tem" -34.5)
desVar("vreg" 0.81)
temp(-34.5)
desVar("pvt0" 1)
desVar("pvt1" 1)
desVar("pvt2" 1)
desVar("pvt3" 1)
desVar("pvt4" 1)
desVar("pvt5" 0)
desVar("pvt6" 0)
desVar("pvt7" 0)
desVar("pvt8" 0)
desVar("pvt9" 0)
desVar("pvt10" 0)
desVar("pvt11" 0)
desVar("pvt12" 0)
desVar("pvt13" 0)
desVar("pvtn0" 0)
desVar("pvtn1" 1)
desVar("pvtn2" 1)
desVar("pvtn3" 1)
desVar("pvtn4" 0)
desVar("pvtn5" 0)
desVar("pvtn6" 0)
desVar("pvtn7" 0)
desVar("pvtn8" 0)
desVar("pvtn9" 0)
desVar("pvtn10" 0)
desVar("pvtn11" 0)
desVar("pvtn12" 0)
desVar("pvtn13" 0)
run()
selectResults('tran)
pup_val = average((clip((v("/vdd" ?result "tran") - v("/outn" ?result "tran")) 2e-07 2.5e-07) / clip(i("/xdrv_p/out" ?result "tran") 2e-07 2.5e-07)))
pdn_val = (average((clip(v("/outp" ?result "tran") 2e-07 2.5e-07) / clip(i("/xdrv_p/out" ?result "tran") 2e-07 2.5e-07))) * -1)
fprintf(out_file "BAD_43,TT,0.81,-34.5,247702070,31,31,31,14,0,17,%f,%f,49.47,49.77\n" pup_val pdn_val)
drain(out_file)
printf("Result BAD_43 -> pup=%f, pdn=%f (GT Target: pup=49.47, pdn=49.77)\n" pup_val pdn_val)

; --- Sim 2/38: [BAD_44] TT, V=0.81V, T=31.0C | ML=(124,60) vs GT=(60,60) ---
printf("\n>>> [JOB 1: TT] Sim 2/38: BAD_44 (TT) V=0.81V, T=31.0C | ML=(124,60) GT=(60,60) <<<\n")
desVar("tem" 31.0)
desVar("vreg" 0.81)
temp(31.0)
desVar("pvt0" 0)
desVar("pvt1" 0)
desVar("pvt2" 1)
desVar("pvt3" 1)
desVar("pvt4" 1)
desVar("pvt5" 1)
desVar("pvt6" 1)
desVar("pvt7" 0)
desVar("pvt8" 0)
desVar("pvt9" 0)
desVar("pvt10" 0)
desVar("pvt11" 0)
desVar("pvt12" 0)
desVar("pvt13" 0)
desVar("pvtn0" 0)
desVar("pvtn1" 0)
desVar("pvtn2" 1)
desVar("pvtn3" 1)
desVar("pvtn4" 1)
desVar("pvtn5" 1)
desVar("pvtn6" 0)
desVar("pvtn7" 0)
desVar("pvtn8" 0)
desVar("pvtn9" 0)
desVar("pvtn10" 0)
desVar("pvtn11" 0)
desVar("pvtn12" 0)
desVar("pvtn13" 0)
run()
selectResults('tran)
pup_val = average((clip((v("/vdd" ?result "tran") - v("/outn" ?result "tran")) 2e-07 2.5e-07) / clip(i("/xdrv_p/out" ?result "tran") 2e-07 2.5e-07)))
pdn_val = (average((clip(v("/outp" ?result "tran") 2e-07 2.5e-07) / clip(i("/xdrv_p/out" ?result "tran") 2e-07 2.5e-07))) * -1)
fprintf(out_file "BAD_44,TT,0.81,31.0,241068330,60,60,124,60,64,0,%f,%f,50.31,49.98\n" pup_val pdn_val)
drain(out_file)
printf("Result BAD_44 -> pup=%f, pdn=%f (GT Target: pup=50.31, pdn=49.98)\n" pup_val pdn_val)

; --- Sim 3/38: [BAD_45] TT, V=0.81V, T=31.5C | ML=(124,60) vs GT=(60,60) ---
printf("\n>>> [JOB 1: TT] Sim 3/38: BAD_45 (TT) V=0.81V, T=31.5C | ML=(124,60) GT=(60,60) <<<\n")
desVar("tem" 31.5)
desVar("vreg" 0.81)
temp(31.5)
desVar("pvt0" 0)
desVar("pvt1" 0)
desVar("pvt2" 1)
desVar("pvt3" 1)
desVar("pvt4" 1)
desVar("pvt5" 1)
desVar("pvt6" 1)
desVar("pvt7" 0)
desVar("pvt8" 0)
desVar("pvt9" 0)
desVar("pvt10" 0)
desVar("pvt11" 0)
desVar("pvt12" 0)
desVar("pvt13" 0)
desVar("pvtn0" 0)
desVar("pvtn1" 0)
desVar("pvtn2" 1)
desVar("pvtn3" 1)
desVar("pvtn4" 1)
desVar("pvtn5" 1)
desVar("pvtn6" 0)
desVar("pvtn7" 0)
desVar("pvtn8" 0)
desVar("pvtn9" 0)
desVar("pvtn10" 0)
desVar("pvtn11" 0)
desVar("pvtn12" 0)
desVar("pvtn13" 0)
run()
selectResults('tran)
pup_val = average((clip((v("/vdd" ?result "tran") - v("/outn" ?result "tran")) 2e-07 2.5e-07) / clip(i("/xdrv_p/out" ?result "tran") 2e-07 2.5e-07)))
pdn_val = (average((clip(v("/outp" ?result "tran") 2e-07 2.5e-07) / clip(i("/xdrv_p/out" ?result "tran") 2e-07 2.5e-07))) * -1)
fprintf(out_file "BAD_45,TT,0.81,31.5,241054530,60,60,124,60,64,0,%f,%f,50.32,49.99\n" pup_val pdn_val)
drain(out_file)
printf("Result BAD_45 -> pup=%f, pdn=%f (GT Target: pup=50.32, pdn=49.99)\n" pup_val pdn_val)

; --- Sim 4/38: [BAD_46] TT, V=0.81V, T=45.5C | ML=(61,60) vs GT=(60,60) ---
printf("\n>>> [JOB 1: TT] Sim 4/38: BAD_46 (TT) V=0.81V, T=45.5C | ML=(61,60) GT=(60,60) <<<\n")
desVar("tem" 45.5)
desVar("vreg" 0.81)
temp(45.5)
desVar("pvt0" 1)
desVar("pvt1" 0)
desVar("pvt2" 1)
desVar("pvt3" 1)
desVar("pvt4" 1)
desVar("pvt5" 1)
desVar("pvt6" 0)
desVar("pvt7" 0)
desVar("pvt8" 0)
desVar("pvt9" 0)
desVar("pvt10" 0)
desVar("pvt11" 0)
desVar("pvt12" 0)
desVar("pvt13" 0)
desVar("pvtn0" 0)
desVar("pvtn1" 0)
desVar("pvtn2" 1)
desVar("pvtn3" 1)
desVar("pvtn4" 1)
desVar("pvtn5" 1)
desVar("pvtn6" 0)
desVar("pvtn7" 0)
desVar("pvtn8" 0)
desVar("pvtn9" 0)
desVar("pvtn10" 0)
desVar("pvtn11" 0)
desVar("pvtn12" 0)
desVar("pvtn13" 0)
run()
selectResults('tran)
pup_val = average((clip((v("/vdd" ?result "tran") - v("/outn" ?result "tran")) 2e-07 2.5e-07) / clip(i("/xdrv_p/out" ?result "tran") 2e-07 2.5e-07)))
pdn_val = (average((clip(v("/outp" ?result "tran") 2e-07 2.5e-07) / clip(i("/xdrv_p/out" ?result "tran") 2e-07 2.5e-07))) * -1)
fprintf(out_file "BAD_46,TT,0.81,45.5,240289320,60,60,61,60,1,0,%f,%f,50.7,50.3\n" pup_val pdn_val)
drain(out_file)
printf("Result BAD_46 -> pup=%f, pdn=%f (GT Target: pup=50.7, pdn=50.3)\n" pup_val pdn_val)

; --- Sim 5/38: [BAD_47] TT, V=0.83V, T=63.0C | ML=(61,60) vs GT=(61,61) ---
printf("\n>>> [JOB 1: TT] Sim 5/38: BAD_47 (TT) V=0.83V, T=63.0C | ML=(61,60) GT=(61,61) <<<\n")
desVar("tem" 63.0)
desVar("vreg" 0.83)
temp(63.0)
desVar("pvt0" 1)
desVar("pvt1" 0)
desVar("pvt2" 1)
desVar("pvt3" 1)
desVar("pvt4" 1)
desVar("pvt5" 1)
desVar("pvt6" 0)
desVar("pvt7" 0)
desVar("pvt8" 0)
desVar("pvt9" 0)
desVar("pvt10" 0)
desVar("pvt11" 0)
desVar("pvt12" 0)
desVar("pvt13" 0)
desVar("pvtn0" 0)
desVar("pvtn1" 0)
desVar("pvtn2" 1)
desVar("pvtn3" 1)
desVar("pvtn4" 1)
desVar("pvtn5" 1)
desVar("pvtn6" 0)
desVar("pvtn7" 0)
desVar("pvtn8" 0)
desVar("pvtn9" 0)
desVar("pvtn10" 0)
desVar("pvtn11" 0)
desVar("pvtn12" 0)
desVar("pvtn13" 0)
run()
selectResults('tran)
pup_val = average((clip((v("/vdd" ?result "tran") - v("/outn" ?result "tran")) 2e-07 2.5e-07) / clip(i("/xdrv_p/out" ?result "tran") 2e-07 2.5e-07)))
pdn_val = (average((clip(v("/outp" ?result "tran") 2e-07 2.5e-07) / clip(i("/xdrv_p/out" ?result "tran") 2e-07 2.5e-07))) * -1)
fprintf(out_file "BAD_47,TT,0.83,63.0,251889710,61,61,61,60,0,1,%f,%f,49.67,49.25\n" pup_val pdn_val)
drain(out_file)
printf("Result BAD_47 -> pup=%f, pdn=%f (GT Target: pup=49.67, pdn=49.25)\n" pup_val pdn_val)

; --- Sim 6/38: [BAD_48] TT, V=0.83V, T=95.5C | ML=(62,61) vs GT=(61,61) ---
printf("\n>>> [JOB 1: TT] Sim 6/38: BAD_48 (TT) V=0.83V, T=95.5C | ML=(62,61) GT=(61,61) <<<\n")
desVar("tem" 95.5)
desVar("vreg" 0.83)
temp(95.5)
desVar("pvt0" 0)
desVar("pvt1" 1)
desVar("pvt2" 1)
desVar("pvt3" 1)
desVar("pvt4" 1)
desVar("pvt5" 1)
desVar("pvt6" 0)
desVar("pvt7" 0)
desVar("pvt8" 0)
desVar("pvt9" 0)
desVar("pvt10" 0)
desVar("pvt11" 0)
desVar("pvt12" 0)
desVar("pvt13" 0)
desVar("pvtn0" 1)
desVar("pvtn1" 0)
desVar("pvtn2" 1)
desVar("pvtn3" 1)
desVar("pvtn4" 1)
desVar("pvtn5" 1)
desVar("pvtn6" 0)
desVar("pvtn7" 0)
desVar("pvtn8" 0)
desVar("pvtn9" 0)
desVar("pvtn10" 0)
desVar("pvtn11" 0)
desVar("pvtn12" 0)
desVar("pvtn13" 0)
run()
selectResults('tran)
pup_val = average((clip((v("/vdd" ?result "tran") - v("/outn" ?result "tran")) 2e-07 2.5e-07) / clip(i("/xdrv_p/out" ?result "tran") 2e-07 2.5e-07)))
pdn_val = (average((clip(v("/outp" ?result "tran") 2e-07 2.5e-07) / clip(i("/xdrv_p/out" ?result "tran") 2e-07 2.5e-07))) * -1)
fprintf(out_file "BAD_48,TT,0.83,95.5,250046680,61,61,62,61,1,0,%f,%f,50.69,49.94\n" pup_val pdn_val)
drain(out_file)
printf("Result BAD_48 -> pup=%f, pdn=%f (GT Target: pup=50.69, pdn=49.94)\n" pup_val pdn_val)

; --- Sim 7/38: [BAD_49] TT, V=0.85V, T=23.0C | ML=(60,31) vs GT=(31,31) ---
printf("\n>>> [JOB 1: TT] Sim 7/38: BAD_49 (TT) V=0.85V, T=23.0C | ML=(60,31) GT=(31,31) <<<\n")
desVar("tem" 23.0)
desVar("vreg" 0.85)
temp(23.0)
desVar("pvt0" 0)
desVar("pvt1" 0)
desVar("pvt2" 1)
desVar("pvt3" 1)
desVar("pvt4" 1)
desVar("pvt5" 1)
desVar("pvt6" 0)
desVar("pvt7" 0)
desVar("pvt8" 0)
desVar("pvt9" 0)
desVar("pvt10" 0)
desVar("pvt11" 0)
desVar("pvt12" 0)
desVar("pvt13" 0)
desVar("pvtn0" 1)
desVar("pvtn1" 1)
desVar("pvtn2" 1)
desVar("pvtn3" 1)
desVar("pvtn4" 1)
desVar("pvtn5" 0)
desVar("pvtn6" 0)
desVar("pvtn7" 0)
desVar("pvtn8" 0)
desVar("pvtn9" 0)
desVar("pvtn10" 0)
desVar("pvtn11" 0)
desVar("pvtn12" 0)
desVar("pvtn13" 0)
run()
selectResults('tran)
pup_val = average((clip((v("/vdd" ?result "tran") - v("/outn" ?result "tran")) 2e-07 2.5e-07) / clip(i("/xdrv_p/out" ?result "tran") 2e-07 2.5e-07)))
pdn_val = (average((clip(v("/outp" ?result "tran") 2e-07 2.5e-07) / clip(i("/xdrv_p/out" ?result "tran") 2e-07 2.5e-07))) * -1)
fprintf(out_file "BAD_49,TT,0.85,23.0,269018780,31,31,60,31,29,0,%f,%f,50.69,50.39\n" pup_val pdn_val)
drain(out_file)
printf("Result BAD_49 -> pup=%f, pdn=%f (GT Target: pup=50.69, pdn=50.39)\n" pup_val pdn_val)

; --- Sim 8/38: [BAD_50] TT, V=0.85V, T=35.5C | ML=(60,31) vs GT=(60,60) ---
printf("\n>>> [JOB 1: TT] Sim 8/38: BAD_50 (TT) V=0.85V, T=35.5C | ML=(60,31) GT=(60,60) <<<\n")
desVar("tem" 35.5)
desVar("vreg" 0.85)
temp(35.5)
desVar("pvt0" 0)
desVar("pvt1" 0)
desVar("pvt2" 1)
desVar("pvt3" 1)
desVar("pvt4" 1)
desVar("pvt5" 1)
desVar("pvt6" 0)
desVar("pvt7" 0)
desVar("pvt8" 0)
desVar("pvt9" 0)
desVar("pvt10" 0)
desVar("pvt11" 0)
desVar("pvt12" 0)
desVar("pvt13" 0)
desVar("pvtn0" 1)
desVar("pvtn1" 1)
desVar("pvtn2" 1)
desVar("pvtn3" 1)
desVar("pvtn4" 1)
desVar("pvtn5" 0)
desVar("pvtn6" 0)
desVar("pvtn7" 0)
desVar("pvtn8" 0)
desVar("pvtn9" 0)
desVar("pvtn10" 0)
desVar("pvtn11" 0)
desVar("pvtn12" 0)
desVar("pvtn13" 0)
run()
selectResults('tran)
pup_val = average((clip((v("/vdd" ?result "tran") - v("/outn" ?result "tran")) 2e-07 2.5e-07) / clip(i("/xdrv_p/out" ?result "tran") 2e-07 2.5e-07)))
pdn_val = (average((clip(v("/outp" ?result "tran") 2e-07 2.5e-07) / clip(i("/xdrv_p/out" ?result "tran") 2e-07 2.5e-07))) * -1)
fprintf(out_file "BAD_50,TT,0.85,35.5,267232530,60,60,60,31,0,29,%f,%f,49.8,49.6\n" pup_val pdn_val)
drain(out_file)
printf("Result BAD_50 -> pup=%f, pdn=%f (GT Target: pup=49.8, pdn=49.6)\n" pup_val pdn_val)

; --- Sim 9/38: [BAD_51] TT, V=0.85V, T=105.0C | ML=(61,61) vs GT=(62,61) ---
printf("\n>>> [JOB 1: TT] Sim 9/38: BAD_51 (TT) V=0.85V, T=105.0C | ML=(61,61) GT=(62,61) <<<\n")
desVar("tem" 105.0)
desVar("vreg" 0.85)
temp(105.0)
desVar("pvt0" 1)
desVar("pvt1" 0)
desVar("pvt2" 1)
desVar("pvt3" 1)
desVar("pvt4" 1)
desVar("pvt5" 1)
desVar("pvt6" 0)
desVar("pvt7" 0)
desVar("pvt8" 0)
desVar("pvt9" 0)
desVar("pvt10" 0)
desVar("pvt11" 0)
desVar("pvt12" 0)
desVar("pvt13" 0)
desVar("pvtn0" 1)
desVar("pvtn1" 0)
desVar("pvtn2" 1)
desVar("pvtn3" 1)
desVar("pvtn4" 1)
desVar("pvtn5" 1)
desVar("pvtn6" 0)
desVar("pvtn7" 0)
desVar("pvtn8" 0)
desVar("pvtn9" 0)
desVar("pvtn10" 0)
desVar("pvtn11" 0)
desVar("pvtn12" 0)
desVar("pvtn13" 0)
run()
selectResults('tran)
pup_val = average((clip((v("/vdd" ?result "tran") - v("/outn" ?result "tran")) 2e-07 2.5e-07) / clip(i("/xdrv_p/out" ?result "tran") 2e-07 2.5e-07)))
pdn_val = (average((clip(v("/outp" ?result "tran") 2e-07 2.5e-07) / clip(i("/xdrv_p/out" ?result "tran") 2e-07 2.5e-07))) * -1)
fprintf(out_file "BAD_51,TT,0.85,105.0,260448600,62,61,61,61,1,0,%f,%f,49.51,49.91\n" pup_val pdn_val)
drain(out_file)
printf("Result BAD_51 -> pup=%f, pdn=%f (GT Target: pup=49.51, pdn=49.91)\n" pup_val pdn_val)

; --- Sim 10/38: [BAD_52] TT, V=0.87V, T=31.0C | ML=(122,31) vs GT=(31,31) ---
printf("\n>>> [JOB 1: TT] Sim 10/38: BAD_52 (TT) V=0.87V, T=31.0C | ML=(122,31) GT=(31,31) <<<\n")
desVar("tem" 31.0)
desVar("vreg" 0.87)
temp(31.0)
desVar("pvt0" 0)
desVar("pvt1" 1)
desVar("pvt2" 0)
desVar("pvt3" 1)
desVar("pvt4" 1)
desVar("pvt5" 1)
desVar("pvt6" 1)
desVar("pvt7" 0)
desVar("pvt8" 0)
desVar("pvt9" 0)
desVar("pvt10" 0)
desVar("pvt11" 0)
desVar("pvt12" 0)
desVar("pvt13" 0)
desVar("pvtn0" 1)
desVar("pvtn1" 1)
desVar("pvtn2" 1)
desVar("pvtn3" 1)
desVar("pvtn4" 1)
desVar("pvtn5" 0)
desVar("pvtn6" 0)
desVar("pvtn7" 0)
desVar("pvtn8" 0)
desVar("pvtn9" 0)
desVar("pvtn10" 0)
desVar("pvtn11" 0)
desVar("pvtn12" 0)
desVar("pvtn13" 0)
run()
selectResults('tran)
pup_val = average((clip((v("/vdd" ?result "tran") - v("/outn" ?result "tran")) 2e-07 2.5e-07) / clip(i("/xdrv_p/out" ?result "tran") 2e-07 2.5e-07)))
pdn_val = (average((clip(v("/outp" ?result "tran") 2e-07 2.5e-07) / clip(i("/xdrv_p/out" ?result "tran") 2e-07 2.5e-07))) * -1)
fprintf(out_file "BAD_52,TT,0.87,31.0,280928170,31,31,122,31,91,0,%f,%f,50.65,50.38\n" pup_val pdn_val)
drain(out_file)
printf("Result BAD_52 -> pup=%f, pdn=%f (GT Target: pup=50.65, pdn=50.38)\n" pup_val pdn_val)

; --- Sim 11/38: [BAD_53] TT, V=0.87V, T=31.5C | ML=(122,31) vs GT=(31,31) ---
printf("\n>>> [JOB 1: TT] Sim 11/38: BAD_53 (TT) V=0.87V, T=31.5C | ML=(122,31) GT=(31,31) <<<\n")
desVar("tem" 31.5)
desVar("vreg" 0.87)
temp(31.5)
desVar("pvt0" 0)
desVar("pvt1" 1)
desVar("pvt2" 0)
desVar("pvt3" 1)
desVar("pvt4" 1)
desVar("pvt5" 1)
desVar("pvt6" 1)
desVar("pvt7" 0)
desVar("pvt8" 0)
desVar("pvt9" 0)
desVar("pvt10" 0)
desVar("pvt11" 0)
desVar("pvt12" 0)
desVar("pvt13" 0)
desVar("pvtn0" 1)
desVar("pvtn1" 1)
desVar("pvtn2" 1)
desVar("pvtn3" 1)
desVar("pvtn4" 1)
desVar("pvtn5" 0)
desVar("pvtn6" 0)
desVar("pvtn7" 0)
desVar("pvtn8" 0)
desVar("pvtn9" 0)
desVar("pvtn10" 0)
desVar("pvtn11" 0)
desVar("pvtn12" 0)
desVar("pvtn13" 0)
run()
selectResults('tran)
pup_val = average((clip((v("/vdd" ?result "tran") - v("/outn" ?result "tran")) 2e-07 2.5e-07) / clip(i("/xdrv_p/out" ?result "tran") 2e-07 2.5e-07)))
pdn_val = (average((clip(v("/outp" ?result "tran") 2e-07 2.5e-07) / clip(i("/xdrv_p/out" ?result "tran") 2e-07 2.5e-07))) * -1)
fprintf(out_file "BAD_53,TT,0.87,31.5,280842670,31,31,122,31,91,0,%f,%f,50.66,50.39\n" pup_val pdn_val)
drain(out_file)
printf("Result BAD_53 -> pup=%f, pdn=%f (GT Target: pup=50.66, pdn=50.39)\n" pup_val pdn_val)

; --- Sim 12/38: [BAD_54] TT, V=0.87V, T=124.0C | ML=(62,127) vs GT=(62,61) ---
printf("\n>>> [JOB 1: TT] Sim 12/38: BAD_54 (TT) V=0.87V, T=124.0C | ML=(62,127) GT=(62,61) <<<\n")
desVar("tem" 124.0)
desVar("vreg" 0.87)
temp(124.0)
desVar("pvt0" 0)
desVar("pvt1" 1)
desVar("pvt2" 1)
desVar("pvt3" 1)
desVar("pvt4" 1)
desVar("pvt5" 1)
desVar("pvt6" 0)
desVar("pvt7" 0)
desVar("pvt8" 0)
desVar("pvt9" 0)
desVar("pvt10" 0)
desVar("pvt11" 0)
desVar("pvt12" 0)
desVar("pvt13" 0)
desVar("pvtn0" 1)
desVar("pvtn1" 1)
desVar("pvtn2" 1)
desVar("pvtn3" 1)
desVar("pvtn4" 1)
desVar("pvtn5" 1)
desVar("pvtn6" 1)
desVar("pvtn7" 0)
desVar("pvtn8" 0)
desVar("pvtn9" 0)
desVar("pvtn10" 0)
desVar("pvtn11" 0)
desVar("pvtn12" 0)
desVar("pvtn13" 0)
run()
selectResults('tran)
pup_val = average((clip((v("/vdd" ?result "tran") - v("/outn" ?result "tran")) 2e-07 2.5e-07) / clip(i("/xdrv_p/out" ?result "tran") 2e-07 2.5e-07)))
pdn_val = (average((clip(v("/outp" ?result "tran") 2e-07 2.5e-07) / clip(i("/xdrv_p/out" ?result "tran") 2e-07 2.5e-07))) * -1)
fprintf(out_file "BAD_54,TT,0.87,124.0,269348730,62,61,62,127,0,66,%f,%f,49.94,50.1\n" pup_val pdn_val)
drain(out_file)
printf("Result BAD_54 -> pup=%f, pdn=%f (GT Target: pup=49.94, pdn=50.1)\n" pup_val pdn_val)

; --- Sim 13/38: [BAD_55] TT, V=0.87V, T=124.5C | ML=(62,127) vs GT=(62,61) ---
printf("\n>>> [JOB 1: TT] Sim 13/38: BAD_55 (TT) V=0.87V, T=124.5C | ML=(62,127) GT=(62,61) <<<\n")
desVar("tem" 124.5)
desVar("vreg" 0.87)
temp(124.5)
desVar("pvt0" 0)
desVar("pvt1" 1)
desVar("pvt2" 1)
desVar("pvt3" 1)
desVar("pvt4" 1)
desVar("pvt5" 1)
desVar("pvt6" 0)
desVar("pvt7" 0)
desVar("pvt8" 0)
desVar("pvt9" 0)
desVar("pvt10" 0)
desVar("pvt11" 0)
desVar("pvt12" 0)
desVar("pvt13" 0)
desVar("pvtn0" 1)
desVar("pvtn1" 1)
desVar("pvtn2" 1)
desVar("pvtn3" 1)
desVar("pvtn4" 1)
desVar("pvtn5" 1)
desVar("pvtn6" 1)
desVar("pvtn7" 0)
desVar("pvtn8" 0)
desVar("pvtn9" 0)
desVar("pvtn10" 0)
desVar("pvtn11" 0)
desVar("pvtn12" 0)
desVar("pvtn13" 0)
run()
selectResults('tran)
pup_val = average((clip((v("/vdd" ?result "tran") - v("/outn" ?result "tran")) 2e-07 2.5e-07) / clip(i("/xdrv_p/out" ?result "tran") 2e-07 2.5e-07)))
pdn_val = (average((clip(v("/outp" ?result "tran") 2e-07 2.5e-07) / clip(i("/xdrv_p/out" ?result "tran") 2e-07 2.5e-07))) * -1)
fprintf(out_file "BAD_55,TT,0.87,124.5,269313590,62,61,62,127,0,66,%f,%f,49.96,50.11\n" pup_val pdn_val)
drain(out_file)
printf("Result BAD_55 -> pup=%f, pdn=%f (GT Target: pup=49.96, pdn=50.11)\n" pup_val pdn_val)

; --- Sim 14/38: [BAD_56] TT, V=0.87V, T=125.0C | ML=(62,127) vs GT=(62,61) ---
printf("\n>>> [JOB 1: TT] Sim 14/38: BAD_56 (TT) V=0.87V, T=125.0C | ML=(62,127) GT=(62,61) <<<\n")
desVar("tem" 125.0)
desVar("vreg" 0.87)
temp(125.0)
desVar("pvt0" 0)
desVar("pvt1" 1)
desVar("pvt2" 1)
desVar("pvt3" 1)
desVar("pvt4" 1)
desVar("pvt5" 1)
desVar("pvt6" 0)
desVar("pvt7" 0)
desVar("pvt8" 0)
desVar("pvt9" 0)
desVar("pvt10" 0)
desVar("pvt11" 0)
desVar("pvt12" 0)
desVar("pvt13" 0)
desVar("pvtn0" 1)
desVar("pvtn1" 1)
desVar("pvtn2" 1)
desVar("pvtn3" 1)
desVar("pvtn4" 1)
desVar("pvtn5" 1)
desVar("pvtn6" 1)
desVar("pvtn7" 0)
desVar("pvtn8" 0)
desVar("pvtn9" 0)
desVar("pvtn10" 0)
desVar("pvtn11" 0)
desVar("pvtn12" 0)
desVar("pvtn13" 0)
run()
selectResults('tran)
pup_val = average((clip((v("/vdd" ?result "tran") - v("/outn" ?result "tran")) 2e-07 2.5e-07) / clip(i("/xdrv_p/out" ?result "tran") 2e-07 2.5e-07)))
pdn_val = (average((clip(v("/outp" ?result "tran") 2e-07 2.5e-07) / clip(i("/xdrv_p/out" ?result "tran") 2e-07 2.5e-07))) * -1)
fprintf(out_file "BAD_56,TT,0.87,125.0,269262550,62,61,62,127,0,66,%f,%f,49.98,50.12\n" pup_val pdn_val)
drain(out_file)
printf("Result BAD_56 -> pup=%f, pdn=%f (GT Target: pup=49.98, pdn=50.12)\n" pup_val pdn_val)

; --- Sim 15/38: [BAD_57] TT, V=0.89V, T=-36.5C | ML=(30,14) vs GT=(30,30) ---
printf("\n>>> [JOB 1: TT] Sim 15/38: BAD_57 (TT) V=0.89V, T=-36.5C | ML=(30,14) GT=(30,30) <<<\n")
desVar("tem" -36.5)
desVar("vreg" 0.89)
temp(-36.5)
desVar("pvt0" 0)
desVar("pvt1" 1)
desVar("pvt2" 1)
desVar("pvt3" 1)
desVar("pvt4" 1)
desVar("pvt5" 0)
desVar("pvt6" 0)
desVar("pvt7" 0)
desVar("pvt8" 0)
desVar("pvt9" 0)
desVar("pvt10" 0)
desVar("pvt11" 0)
desVar("pvt12" 0)
desVar("pvt13" 0)
desVar("pvtn0" 0)
desVar("pvtn1" 1)
desVar("pvtn2" 1)
desVar("pvtn3" 1)
desVar("pvtn4" 0)
desVar("pvtn5" 0)
desVar("pvtn6" 0)
desVar("pvtn7" 0)
desVar("pvtn8" 0)
desVar("pvtn9" 0)
desVar("pvtn10" 0)
desVar("pvtn11" 0)
desVar("pvtn12" 0)
desVar("pvtn13" 0)
run()
selectResults('tran)
pup_val = average((clip((v("/vdd" ?result "tran") - v("/outn" ?result "tran")) 2e-07 2.5e-07) / clip(i("/xdrv_p/out" ?result "tran") 2e-07 2.5e-07)))
pdn_val = (average((clip(v("/outp" ?result "tran") 2e-07 2.5e-07) / clip(i("/xdrv_p/out" ?result "tran") 2e-07 2.5e-07))) * -1)
fprintf(out_file "BAD_57,TT,0.89,-36.5,313270140,30,30,30,14,0,16,%f,%f,49.82,49.78\n" pup_val pdn_val)
drain(out_file)
printf("Result BAD_57 -> pup=%f, pdn=%f (GT Target: pup=49.82, pdn=49.78)\n" pup_val pdn_val)

; --- Sim 16/38: [BAD_58] TT, V=0.89V, T=-4.5C | ML=(31,30) vs GT=(30,30) ---
printf("\n>>> [JOB 1: TT] Sim 16/38: BAD_58 (TT) V=0.89V, T=-4.5C | ML=(31,30) GT=(30,30) <<<\n")
desVar("tem" -4.5)
desVar("vreg" 0.89)
temp(-4.5)
desVar("pvt0" 1)
desVar("pvt1" 1)
desVar("pvt2" 1)
desVar("pvt3" 1)
desVar("pvt4" 1)
desVar("pvt5" 0)
desVar("pvt6" 0)
desVar("pvt7" 0)
desVar("pvt8" 0)
desVar("pvt9" 0)
desVar("pvt10" 0)
desVar("pvt11" 0)
desVar("pvt12" 0)
desVar("pvt13" 0)
desVar("pvtn0" 0)
desVar("pvtn1" 1)
desVar("pvtn2" 1)
desVar("pvtn3" 1)
desVar("pvtn4" 1)
desVar("pvtn5" 0)
desVar("pvtn6" 0)
desVar("pvtn7" 0)
desVar("pvtn8" 0)
desVar("pvtn9" 0)
desVar("pvtn10" 0)
desVar("pvtn11" 0)
desVar("pvtn12" 0)
desVar("pvtn13" 0)
run()
selectResults('tran)
pup_val = average((clip((v("/vdd" ?result "tran") - v("/outn" ?result "tran")) 2e-07 2.5e-07) / clip(i("/xdrv_p/out" ?result "tran") 2e-07 2.5e-07)))
pdn_val = (average((clip(v("/outp" ?result "tran") 2e-07 2.5e-07) / clip(i("/xdrv_p/out" ?result "tran") 2e-07 2.5e-07))) * -1)
fprintf(out_file "BAD_58,TT,0.89,-4.5,302623780,30,30,31,30,1,0,%f,%f,50.69,50.59\n" pup_val pdn_val)
drain(out_file)
printf("Result BAD_58 -> pup=%f, pdn=%f (GT Target: pup=50.69, pdn=50.59)\n" pup_val pdn_val)

; --- Sim 17/38: [BAD_59] TT, V=0.89V, T=0.0C | ML=(31,30) vs GT=(31,31) ---
printf("\n>>> [JOB 1: TT] Sim 17/38: BAD_59 (TT) V=0.89V, T=0.0C | ML=(31,30) GT=(31,31) <<<\n")
desVar("tem" 0.0)
desVar("vreg" 0.89)
temp(0.0)
desVar("pvt0" 1)
desVar("pvt1" 1)
desVar("pvt2" 1)
desVar("pvt3" 1)
desVar("pvt4" 1)
desVar("pvt5" 0)
desVar("pvt6" 0)
desVar("pvt7" 0)
desVar("pvt8" 0)
desVar("pvt9" 0)
desVar("pvt10" 0)
desVar("pvt11" 0)
desVar("pvt12" 0)
desVar("pvt13" 0)
desVar("pvtn0" 0)
desVar("pvtn1" 1)
desVar("pvtn2" 1)
desVar("pvtn3" 1)
desVar("pvtn4" 1)
desVar("pvtn5" 0)
desVar("pvtn6" 0)
desVar("pvtn7" 0)
desVar("pvtn8" 0)
desVar("pvtn9" 0)
desVar("pvtn10" 0)
desVar("pvtn11" 0)
desVar("pvtn12" 0)
desVar("pvtn13" 0)
run()
selectResults('tran)
pup_val = average((clip((v("/vdd" ?result "tran") - v("/outn" ?result "tran")) 2e-07 2.5e-07) / clip(i("/xdrv_p/out" ?result "tran") 2e-07 2.5e-07)))
pdn_val = (average((clip(v("/outp" ?result "tran") 2e-07 2.5e-07) / clip(i("/xdrv_p/out" ?result "tran") 2e-07 2.5e-07))) * -1)
fprintf(out_file "BAD_59,TT,0.89,0.0,301362760,31,31,31,30,0,1,%f,%f,49.53,49.44\n" pup_val pdn_val)
drain(out_file)
printf("Result BAD_59 -> pup=%f, pdn=%f (GT Target: pup=49.53, pdn=49.44)\n" pup_val pdn_val)

; --- Sim 18/38: [BAD_60] TT, V=0.89V, T=84.0C | ML=(60,60) vs GT=(61,60) ---
printf("\n>>> [JOB 1: TT] Sim 18/38: BAD_60 (TT) V=0.89V, T=84.0C | ML=(60,60) GT=(61,60) <<<\n")
desVar("tem" 84.0)
desVar("vreg" 0.89)
temp(84.0)
desVar("pvt0" 0)
desVar("pvt1" 0)
desVar("pvt2" 1)
desVar("pvt3" 1)
desVar("pvt4" 1)
desVar("pvt5" 1)
desVar("pvt6" 0)
desVar("pvt7" 0)
desVar("pvt8" 0)
desVar("pvt9" 0)
desVar("pvt10" 0)
desVar("pvt11" 0)
desVar("pvt12" 0)
desVar("pvt13" 0)
desVar("pvtn0" 0)
desVar("pvtn1" 0)
desVar("pvtn2" 1)
desVar("pvtn3" 1)
desVar("pvtn4" 1)
desVar("pvtn5" 1)
desVar("pvtn6" 0)
desVar("pvtn7" 0)
desVar("pvtn8" 0)
desVar("pvtn9" 0)
desVar("pvtn10" 0)
desVar("pvtn11" 0)
desVar("pvtn12" 0)
desVar("pvtn13" 0)
run()
selectResults('tran)
pup_val = average((clip((v("/vdd" ?result "tran") - v("/outn" ?result "tran")) 2e-07 2.5e-07) / clip(i("/xdrv_p/out" ?result "tran") 2e-07 2.5e-07)))
pdn_val = (average((clip(v("/outp" ?result "tran") 2e-07 2.5e-07) / clip(i("/xdrv_p/out" ?result "tran") 2e-07 2.5e-07))) * -1)
fprintf(out_file "BAD_60,TT,0.89,84.0,284320560,61,60,60,60,1,0,%f,%f,49.48,50.26\n" pup_val pdn_val)
drain(out_file)
printf("Result BAD_60 -> pup=%f, pdn=%f (GT Target: pup=49.48, pdn=50.26)\n" pup_val pdn_val)

; --- Sim 19/38: [BAD_61] TT, V=0.91V, T=6.5C | ML=(31,124) vs GT=(31,30) ---
printf("\n>>> [JOB 1: TT] Sim 19/38: BAD_61 (TT) V=0.91V, T=6.5C | ML=(31,124) GT=(31,30) <<<\n")
desVar("tem" 6.5)
desVar("vreg" 0.91)
temp(6.5)
desVar("pvt0" 1)
desVar("pvt1" 1)
desVar("pvt2" 1)
desVar("pvt3" 1)
desVar("pvt4" 1)
desVar("pvt5" 0)
desVar("pvt6" 0)
desVar("pvt7" 0)
desVar("pvt8" 0)
desVar("pvt9" 0)
desVar("pvt10" 0)
desVar("pvt11" 0)
desVar("pvt12" 0)
desVar("pvt13" 0)
desVar("pvtn0" 0)
desVar("pvtn1" 0)
desVar("pvtn2" 1)
desVar("pvtn3" 1)
desVar("pvtn4" 1)
desVar("pvtn5" 1)
desVar("pvtn6" 1)
desVar("pvtn7" 0)
desVar("pvtn8" 0)
desVar("pvtn9" 0)
desVar("pvtn10" 0)
desVar("pvtn11" 0)
desVar("pvtn12" 0)
desVar("pvtn13" 0)
run()
selectResults('tran)
pup_val = average((clip((v("/vdd" ?result "tran") - v("/outn" ?result "tran")) 2e-07 2.5e-07) / clip(i("/xdrv_p/out" ?result "tran") 2e-07 2.5e-07)))
pdn_val = (average((clip(v("/outp" ?result "tran") 2e-07 2.5e-07) / clip(i("/xdrv_p/out" ?result "tran") 2e-07 2.5e-07))) * -1)
fprintf(out_file "BAD_61,TT,0.91,6.5,313166780,31,30,31,124,0,94,%f,%f,49.49,50.67\n" pup_val pdn_val)
drain(out_file)
printf("Result BAD_61 -> pup=%f, pdn=%f (GT Target: pup=49.49, pdn=50.67)\n" pup_val pdn_val)

; --- Sim 20/38: [BAD_62] TT, V=0.91V, T=7.0C | ML=(31,124) vs GT=(31,30) ---
printf("\n>>> [JOB 1: TT] Sim 20/38: BAD_62 (TT) V=0.91V, T=7.0C | ML=(31,124) GT=(31,30) <<<\n")
desVar("tem" 7.0)
desVar("vreg" 0.91)
temp(7.0)
desVar("pvt0" 1)
desVar("pvt1" 1)
desVar("pvt2" 1)
desVar("pvt3" 1)
desVar("pvt4" 1)
desVar("pvt5" 0)
desVar("pvt6" 0)
desVar("pvt7" 0)
desVar("pvt8" 0)
desVar("pvt9" 0)
desVar("pvt10" 0)
desVar("pvt11" 0)
desVar("pvt12" 0)
desVar("pvt13" 0)
desVar("pvtn0" 0)
desVar("pvtn1" 0)
desVar("pvtn2" 1)
desVar("pvtn3" 1)
desVar("pvtn4" 1)
desVar("pvtn5" 1)
desVar("pvtn6" 1)
desVar("pvtn7" 0)
desVar("pvtn8" 0)
desVar("pvtn9" 0)
desVar("pvtn10" 0)
desVar("pvtn11" 0)
desVar("pvtn12" 0)
desVar("pvtn13" 0)
run()
selectResults('tran)
pup_val = average((clip((v("/vdd" ?result "tran") - v("/outn" ?result "tran")) 2e-07 2.5e-07) / clip(i("/xdrv_p/out" ?result "tran") 2e-07 2.5e-07)))
pdn_val = (average((clip(v("/outp" ?result "tran") 2e-07 2.5e-07) / clip(i("/xdrv_p/out" ?result "tran") 2e-07 2.5e-07))) * -1)
fprintf(out_file "BAD_62,TT,0.91,7.0,313029740,31,30,31,124,0,94,%f,%f,49.5,50.68\n" pup_val pdn_val)
drain(out_file)
printf("Result BAD_62 -> pup=%f, pdn=%f (GT Target: pup=49.5, pdn=50.68)\n" pup_val pdn_val)

; --- Sim 21/38: [BAD_63] TT, V=0.91V, T=7.5C | ML=(31,124) vs GT=(31,31) ---
printf("\n>>> [JOB 1: TT] Sim 21/38: BAD_63 (TT) V=0.91V, T=7.5C | ML=(31,124) GT=(31,31) <<<\n")
desVar("tem" 7.5)
desVar("vreg" 0.91)
temp(7.5)
desVar("pvt0" 1)
desVar("pvt1" 1)
desVar("pvt2" 1)
desVar("pvt3" 1)
desVar("pvt4" 1)
desVar("pvt5" 0)
desVar("pvt6" 0)
desVar("pvt7" 0)
desVar("pvt8" 0)
desVar("pvt9" 0)
desVar("pvt10" 0)
desVar("pvt11" 0)
desVar("pvt12" 0)
desVar("pvt13" 0)
desVar("pvtn0" 0)
desVar("pvtn1" 0)
desVar("pvtn2" 1)
desVar("pvtn3" 1)
desVar("pvtn4" 1)
desVar("pvtn5" 1)
desVar("pvtn6" 1)
desVar("pvtn7" 0)
desVar("pvtn8" 0)
desVar("pvtn9" 0)
desVar("pvtn10" 0)
desVar("pvtn11" 0)
desVar("pvtn12" 0)
desVar("pvtn13" 0)
run()
selectResults('tran)
pup_val = average((clip((v("/vdd" ?result "tran") - v("/outn" ?result "tran")) 2e-07 2.5e-07) / clip(i("/xdrv_p/out" ?result "tran") 2e-07 2.5e-07)))
pdn_val = (average((clip(v("/outp" ?result "tran") 2e-07 2.5e-07) / clip(i("/xdrv_p/out" ?result "tran") 2e-07 2.5e-07))) * -1)
fprintf(out_file "BAD_63,TT,0.91,7.5,312860670,31,31,31,124,0,93,%f,%f,49.51,49.44\n" pup_val pdn_val)
drain(out_file)
printf("Result BAD_63 -> pup=%f, pdn=%f (GT Target: pup=49.51, pdn=49.44)\n" pup_val pdn_val)

; --- Sim 22/38: [BAD_64] TT, V=0.91V, T=8.0C | ML=(31,124) vs GT=(31,31) ---
printf("\n>>> [JOB 1: TT] Sim 22/38: BAD_64 (TT) V=0.91V, T=8.0C | ML=(31,124) GT=(31,31) <<<\n")
desVar("tem" 8.0)
desVar("vreg" 0.91)
temp(8.0)
desVar("pvt0" 1)
desVar("pvt1" 1)
desVar("pvt2" 1)
desVar("pvt3" 1)
desVar("pvt4" 1)
desVar("pvt5" 0)
desVar("pvt6" 0)
desVar("pvt7" 0)
desVar("pvt8" 0)
desVar("pvt9" 0)
desVar("pvt10" 0)
desVar("pvt11" 0)
desVar("pvt12" 0)
desVar("pvt13" 0)
desVar("pvtn0" 0)
desVar("pvtn1" 0)
desVar("pvtn2" 1)
desVar("pvtn3" 1)
desVar("pvtn4" 1)
desVar("pvtn5" 1)
desVar("pvtn6" 1)
desVar("pvtn7" 0)
desVar("pvtn8" 0)
desVar("pvtn9" 0)
desVar("pvtn10" 0)
desVar("pvtn11" 0)
desVar("pvtn12" 0)
desVar("pvtn13" 0)
run()
selectResults('tran)
pup_val = average((clip((v("/vdd" ?result "tran") - v("/outn" ?result "tran")) 2e-07 2.5e-07) / clip(i("/xdrv_p/out" ?result "tran") 2e-07 2.5e-07)))
pdn_val = (average((clip(v("/outp" ?result "tran") 2e-07 2.5e-07) / clip(i("/xdrv_p/out" ?result "tran") 2e-07 2.5e-07))) * -1)
fprintf(out_file "BAD_64,TT,0.91,8.0,312722260,31,31,31,124,0,93,%f,%f,49.53,49.45\n" pup_val pdn_val)
drain(out_file)
printf("Result BAD_64 -> pup=%f, pdn=%f (GT Target: pup=49.53, pdn=49.45)\n" pup_val pdn_val)

; --- Sim 23/38: [BAD_65] TT, V=0.93V, T=-3.5C | ML=(122,30) vs GT=(30,30) ---
printf("\n>>> [JOB 1: TT] Sim 23/38: BAD_65 (TT) V=0.93V, T=-3.5C | ML=(122,30) GT=(30,30) <<<\n")
desVar("tem" -3.5)
desVar("vreg" 0.93)
temp(-3.5)
desVar("pvt0" 0)
desVar("pvt1" 1)
desVar("pvt2" 0)
desVar("pvt3" 1)
desVar("pvt4" 1)
desVar("pvt5" 1)
desVar("pvt6" 1)
desVar("pvt7" 0)
desVar("pvt8" 0)
desVar("pvt9" 0)
desVar("pvt10" 0)
desVar("pvt11" 0)
desVar("pvt12" 0)
desVar("pvt13" 0)
desVar("pvtn0" 0)
desVar("pvtn1" 1)
desVar("pvtn2" 1)
desVar("pvtn3" 1)
desVar("pvtn4" 1)
desVar("pvtn5" 0)
desVar("pvtn6" 0)
desVar("pvtn7" 0)
desVar("pvtn8" 0)
desVar("pvtn9" 0)
desVar("pvtn10" 0)
desVar("pvtn11" 0)
desVar("pvtn12" 0)
desVar("pvtn13" 0)
run()
selectResults('tran)
pup_val = average((clip((v("/vdd" ?result "tran") - v("/outn" ?result "tran")) 2e-07 2.5e-07) / clip(i("/xdrv_p/out" ?result "tran") 2e-07 2.5e-07)))
pdn_val = (average((clip(v("/outp" ?result "tran") 2e-07 2.5e-07) / clip(i("/xdrv_p/out" ?result "tran") 2e-07 2.5e-07))) * -1)
fprintf(out_file "BAD_65,TT,0.93,-3.5,330036190,30,30,122,30,92,0,%f,%f,50.29,50.26\n" pup_val pdn_val)
drain(out_file)
printf("Result BAD_65 -> pup=%f, pdn=%f (GT Target: pup=50.29, pdn=50.26)\n" pup_val pdn_val)

; --- Sim 24/38: [BAD_66] TT, V=0.93V, T=15.5C | ML=(31,30) vs GT=(31,31) ---
printf("\n>>> [JOB 1: TT] Sim 24/38: BAD_66 (TT) V=0.93V, T=15.5C | ML=(31,30) GT=(31,31) <<<\n")
desVar("tem" 15.5)
desVar("vreg" 0.93)
temp(15.5)
desVar("pvt0" 1)
desVar("pvt1" 1)
desVar("pvt2" 1)
desVar("pvt3" 1)
desVar("pvt4" 1)
desVar("pvt5" 0)
desVar("pvt6" 0)
desVar("pvt7" 0)
desVar("pvt8" 0)
desVar("pvt9" 0)
desVar("pvt10" 0)
desVar("pvt11" 0)
desVar("pvt12" 0)
desVar("pvt13" 0)
desVar("pvtn0" 0)
desVar("pvtn1" 1)
desVar("pvtn2" 1)
desVar("pvtn3" 1)
desVar("pvtn4" 1)
desVar("pvtn5" 0)
desVar("pvtn6" 0)
desVar("pvtn7" 0)
desVar("pvtn8" 0)
desVar("pvtn9" 0)
desVar("pvtn10" 0)
desVar("pvtn11" 0)
desVar("pvtn12" 0)
desVar("pvtn13" 0)
run()
selectResults('tran)
pup_val = average((clip((v("/vdd" ?result "tran") - v("/outn" ?result "tran")) 2e-07 2.5e-07) / clip(i("/xdrv_p/out" ?result "tran") 2e-07 2.5e-07)))
pdn_val = (average((clip(v("/outp" ?result "tran") 2e-07 2.5e-07) / clip(i("/xdrv_p/out" ?result "tran") 2e-07 2.5e-07))) * -1)
fprintf(out_file "BAD_66,TT,0.93,15.5,323451970,31,31,31,30,0,1,%f,%f,49.53,49.46\n" pup_val pdn_val)
drain(out_file)
printf("Result BAD_66 -> pup=%f, pdn=%f (GT Target: pup=49.53, pdn=49.46)\n" pup_val pdn_val)

; --- Sim 25/38: [BAD_67] TT, V=0.93V, T=118.0C | ML=(61,61) vs GT=(61,60) ---
printf("\n>>> [JOB 1: TT] Sim 25/38: BAD_67 (TT) V=0.93V, T=118.0C | ML=(61,61) GT=(61,60) <<<\n")
desVar("tem" 118.0)
desVar("vreg" 0.93)
temp(118.0)
desVar("pvt0" 1)
desVar("pvt1" 0)
desVar("pvt2" 1)
desVar("pvt3" 1)
desVar("pvt4" 1)
desVar("pvt5" 1)
desVar("pvt6" 0)
desVar("pvt7" 0)
desVar("pvt8" 0)
desVar("pvt9" 0)
desVar("pvt10" 0)
desVar("pvt11" 0)
desVar("pvt12" 0)
desVar("pvt13" 0)
desVar("pvtn0" 1)
desVar("pvtn1" 0)
desVar("pvtn2" 1)
desVar("pvtn3" 1)
desVar("pvtn4" 1)
desVar("pvtn5" 1)
desVar("pvtn6" 0)
desVar("pvtn7" 0)
desVar("pvtn8" 0)
desVar("pvtn9" 0)
desVar("pvtn10" 0)
desVar("pvtn11" 0)
desVar("pvtn12" 0)
desVar("pvtn13" 0)
run()
selectResults('tran)
pup_val = average((clip((v("/vdd" ?result "tran") - v("/outn" ?result "tran")) 2e-07 2.5e-07) / clip(i("/xdrv_p/out" ?result "tran") 2e-07 2.5e-07)))
pdn_val = (average((clip(v("/outp" ?result "tran") 2e-07 2.5e-07) / clip(i("/xdrv_p/out" ?result "tran") 2e-07 2.5e-07))) * -1)
fprintf(out_file "BAD_67,TT,0.93,118.0,299521420,61,60,61,61,0,1,%f,%f,50.18,50.64\n" pup_val pdn_val)
drain(out_file)
printf("Result BAD_67 -> pup=%f, pdn=%f (GT Target: pup=50.18, pdn=50.64)\n" pup_val pdn_val)

; --- Sim 26/38: [BAD_68] TT, V=0.95V, T=-40.0C | ML=(29,29) vs GT=(61,61) ---
printf("\n>>> [JOB 1: TT] Sim 26/38: BAD_68 (TT) V=0.95V, T=-40.0C | ML=(29,29) GT=(61,61) <<<\n")
desVar("tem" -40.0)
desVar("vreg" 0.95)
temp(-40.0)
desVar("pvt0" 1)
desVar("pvt1" 0)
desVar("pvt2" 1)
desVar("pvt3" 1)
desVar("pvt4" 1)
desVar("pvt5" 0)
desVar("pvt6" 0)
desVar("pvt7" 0)
desVar("pvt8" 0)
desVar("pvt9" 0)
desVar("pvt10" 0)
desVar("pvt11" 0)
desVar("pvt12" 0)
desVar("pvt13" 0)
desVar("pvtn0" 1)
desVar("pvtn1" 0)
desVar("pvtn2" 1)
desVar("pvtn3" 1)
desVar("pvtn4" 1)
desVar("pvtn5" 0)
desVar("pvtn6" 0)
desVar("pvtn7" 0)
desVar("pvtn8" 0)
desVar("pvtn9" 0)
desVar("pvtn10" 0)
desVar("pvtn11" 0)
desVar("pvtn12" 0)
desVar("pvtn13" 0)
run()
selectResults('tran)
pup_val = average((clip((v("/vdd" ?result "tran") - v("/outn" ?result "tran")) 2e-07 2.5e-07) / clip(i("/xdrv_p/out" ?result "tran") 2e-07 2.5e-07)))
pdn_val = (average((clip(v("/outp" ?result "tran") 2e-07 2.5e-07) / clip(i("/xdrv_p/out" ?result "tran") 2e-07 2.5e-07))) * -1)
fprintf(out_file "BAD_68,TT,0.95,-40.0,360920620,61,61,29,29,32,32,%f,%f,50.47,49.59\n" pup_val pdn_val)
drain(out_file)
printf("Result BAD_68 -> pup=%f, pdn=%f (GT Target: pup=50.47, pdn=49.59)\n" pup_val pdn_val)

; --- Sim 27/38: [BAD_69] TT, V=0.95V, T=-30.5C | ML=(30,30) vs GT=(29,30) ---
printf("\n>>> [JOB 1: TT] Sim 27/38: BAD_69 (TT) V=0.95V, T=-30.5C | ML=(30,30) GT=(29,30) <<<\n")
desVar("tem" -30.5)
desVar("vreg" 0.95)
temp(-30.5)
desVar("pvt0" 0)
desVar("pvt1" 1)
desVar("pvt2" 1)
desVar("pvt3" 1)
desVar("pvt4" 1)
desVar("pvt5" 0)
desVar("pvt6" 0)
desVar("pvt7" 0)
desVar("pvt8" 0)
desVar("pvt9" 0)
desVar("pvt10" 0)
desVar("pvt11" 0)
desVar("pvt12" 0)
desVar("pvt13" 0)
desVar("pvtn0" 0)
desVar("pvtn1" 1)
desVar("pvtn2" 1)
desVar("pvtn3" 1)
desVar("pvtn4" 1)
desVar("pvtn5" 0)
desVar("pvtn6" 0)
desVar("pvtn7" 0)
desVar("pvtn8" 0)
desVar("pvtn9" 0)
desVar("pvtn10" 0)
desVar("pvtn11" 0)
desVar("pvtn12" 0)
desVar("pvtn13" 0)
run()
selectResults('tran)
pup_val = average((clip((v("/vdd" ?result "tran") - v("/outn" ?result "tran")) 2e-07 2.5e-07) / clip(i("/xdrv_p/out" ?result "tran") 2e-07 2.5e-07)))
pdn_val = (average((clip(v("/outp" ?result "tran") 2e-07 2.5e-07) / clip(i("/xdrv_p/out" ?result "tran") 2e-07 2.5e-07))) * -1)
fprintf(out_file "BAD_69,TT,0.95,-30.5,355867860,29,30,30,30,1,0,%f,%f,50.69,49.44\n" pup_val pdn_val)
drain(out_file)
printf("Result BAD_69 -> pup=%f, pdn=%f (GT Target: pup=50.69, pdn=49.44)\n" pup_val pdn_val)

; --- Sim 28/38: [BAD_70] TT, V=0.95V, T=-20.0C | ML=(122,30) vs GT=(30,30) ---
printf("\n>>> [JOB 1: TT] Sim 28/38: BAD_70 (TT) V=0.95V, T=-20.0C | ML=(122,30) GT=(30,30) <<<\n")
desVar("tem" -20.0)
desVar("vreg" 0.95)
temp(-20.0)
desVar("pvt0" 0)
desVar("pvt1" 1)
desVar("pvt2" 0)
desVar("pvt3" 1)
desVar("pvt4" 1)
desVar("pvt5" 1)
desVar("pvt6" 1)
desVar("pvt7" 0)
desVar("pvt8" 0)
desVar("pvt9" 0)
desVar("pvt10" 0)
desVar("pvt11" 0)
desVar("pvt12" 0)
desVar("pvt13" 0)
desVar("pvtn0" 0)
desVar("pvtn1" 1)
desVar("pvtn2" 1)
desVar("pvtn3" 1)
desVar("pvtn4" 1)
desVar("pvtn5" 0)
desVar("pvtn6" 0)
desVar("pvtn7" 0)
desVar("pvtn8" 0)
desVar("pvtn9" 0)
desVar("pvtn10" 0)
desVar("pvtn11" 0)
desVar("pvtn12" 0)
desVar("pvtn13" 0)
run()
selectResults('tran)
pup_val = average((clip((v("/vdd" ?result "tran") - v("/outn" ?result "tran")) 2e-07 2.5e-07) / clip(i("/xdrv_p/out" ?result "tran") 2e-07 2.5e-07)))
pdn_val = (average((clip(v("/outp" ?result "tran") 2e-07 2.5e-07) / clip(i("/xdrv_p/out" ?result "tran") 2e-07 2.5e-07))) * -1)
fprintf(out_file "BAD_70,TT,0.95,-20.0,350769280,30,30,122,30,92,0,%f,%f,49.66,49.7\n" pup_val pdn_val)
drain(out_file)
printf("Result BAD_70 -> pup=%f, pdn=%f (GT Target: pup=49.66, pdn=49.7)\n" pup_val pdn_val)

; --- Sim 29/38: [BAD_71] TT, V=0.95V, T=-19.5C | ML=(122,30) vs GT=(30,30) ---
printf("\n>>> [JOB 1: TT] Sim 29/38: BAD_71 (TT) V=0.95V, T=-19.5C | ML=(122,30) GT=(30,30) <<<\n")
desVar("tem" -19.5)
desVar("vreg" 0.95)
temp(-19.5)
desVar("pvt0" 0)
desVar("pvt1" 1)
desVar("pvt2" 0)
desVar("pvt3" 1)
desVar("pvt4" 1)
desVar("pvt5" 1)
desVar("pvt6" 1)
desVar("pvt7" 0)
desVar("pvt8" 0)
desVar("pvt9" 0)
desVar("pvt10" 0)
desVar("pvt11" 0)
desVar("pvt12" 0)
desVar("pvt13" 0)
desVar("pvtn0" 0)
desVar("pvtn1" 1)
desVar("pvtn2" 1)
desVar("pvtn3" 1)
desVar("pvtn4" 1)
desVar("pvtn5" 0)
desVar("pvtn6" 0)
desVar("pvtn7" 0)
desVar("pvtn8" 0)
desVar("pvtn9" 0)
desVar("pvtn10" 0)
desVar("pvtn11" 0)
desVar("pvtn12" 0)
desVar("pvtn13" 0)
run()
selectResults('tran)
pup_val = average((clip((v("/vdd" ?result "tran") - v("/outn" ?result "tran")) 2e-07 2.5e-07) / clip(i("/xdrv_p/out" ?result "tran") 2e-07 2.5e-07)))
pdn_val = (average((clip(v("/outp" ?result "tran") 2e-07 2.5e-07) / clip(i("/xdrv_p/out" ?result "tran") 2e-07 2.5e-07))) * -1)
fprintf(out_file "BAD_71,TT,0.95,-19.5,350518830,30,30,122,30,92,0,%f,%f,49.68,49.72\n" pup_val pdn_val)
drain(out_file)
printf("Result BAD_71 -> pup=%f, pdn=%f (GT Target: pup=49.68, pdn=49.72)\n" pup_val pdn_val)

; --- Sim 30/38: [BAD_72] TT, V=0.95V, T=19.5C | ML=(31,124) vs GT=(31,30) ---
printf("\n>>> [JOB 1: TT] Sim 30/38: BAD_72 (TT) V=0.95V, T=19.5C | ML=(31,124) GT=(31,30) <<<\n")
desVar("tem" 19.5)
desVar("vreg" 0.95)
temp(19.5)
desVar("pvt0" 1)
desVar("pvt1" 1)
desVar("pvt2" 1)
desVar("pvt3" 1)
desVar("pvt4" 1)
desVar("pvt5" 0)
desVar("pvt6" 0)
desVar("pvt7" 0)
desVar("pvt8" 0)
desVar("pvt9" 0)
desVar("pvt10" 0)
desVar("pvt11" 0)
desVar("pvt12" 0)
desVar("pvt13" 0)
desVar("pvtn0" 0)
desVar("pvtn1" 0)
desVar("pvtn2" 1)
desVar("pvtn3" 1)
desVar("pvtn4" 1)
desVar("pvtn5" 1)
desVar("pvtn6" 1)
desVar("pvtn7" 0)
desVar("pvtn8" 0)
desVar("pvtn9" 0)
desVar("pvtn10" 0)
desVar("pvtn11" 0)
desVar("pvtn12" 0)
desVar("pvtn13" 0)
run()
selectResults('tran)
pup_val = average((clip((v("/vdd" ?result "tran") - v("/outn" ?result "tran")) 2e-07 2.5e-07) / clip(i("/xdrv_p/out" ?result "tran") 2e-07 2.5e-07)))
pdn_val = (average((clip(v("/outp" ?result "tran") 2e-07 2.5e-07) / clip(i("/xdrv_p/out" ?result "tran") 2e-07 2.5e-07))) * -1)
fprintf(out_file "BAD_72,TT,0.95,19.5,334688510,31,30,31,124,0,94,%f,%f,49.45,50.66\n" pup_val pdn_val)
drain(out_file)
printf("Result BAD_72 -> pup=%f, pdn=%f (GT Target: pup=49.45, pdn=50.66)\n" pup_val pdn_val)

; --- Sim 31/38: [BAD_73] TT, V=0.95V, T=20.0C | ML=(31,31) vs GT=(31,30) ---
printf("\n>>> [JOB 1: TT] Sim 31/38: BAD_73 (TT) V=0.95V, T=20.0C | ML=(31,31) GT=(31,30) <<<\n")
desVar("tem" 20.0)
desVar("vreg" 0.95)
temp(20.0)
desVar("pvt0" 1)
desVar("pvt1" 1)
desVar("pvt2" 1)
desVar("pvt3" 1)
desVar("pvt4" 1)
desVar("pvt5" 0)
desVar("pvt6" 0)
desVar("pvt7" 0)
desVar("pvt8" 0)
desVar("pvt9" 0)
desVar("pvt10" 0)
desVar("pvt11" 0)
desVar("pvt12" 0)
desVar("pvt13" 0)
desVar("pvtn0" 1)
desVar("pvtn1" 1)
desVar("pvtn2" 1)
desVar("pvtn3" 1)
desVar("pvtn4" 1)
desVar("pvtn5" 0)
desVar("pvtn6" 0)
desVar("pvtn7" 0)
desVar("pvtn8" 0)
desVar("pvtn9" 0)
desVar("pvtn10" 0)
desVar("pvtn11" 0)
desVar("pvtn12" 0)
desVar("pvtn13" 0)
run()
selectResults('tran)
pup_val = average((clip((v("/vdd" ?result "tran") - v("/outn" ?result "tran")) 2e-07 2.5e-07) / clip(i("/xdrv_p/out" ?result "tran") 2e-07 2.5e-07)))
pdn_val = (average((clip(v("/outp" ?result "tran") 2e-07 2.5e-07) / clip(i("/xdrv_p/out" ?result "tran") 2e-07 2.5e-07))) * -1)
fprintf(out_file "BAD_73,TT,0.95,20.0,334494080,31,30,31,31,0,1,%f,%f,49.46,50.67\n" pup_val pdn_val)
drain(out_file)
printf("Result BAD_73 -> pup=%f, pdn=%f (GT Target: pup=49.46, pdn=50.67)\n" pup_val pdn_val)

; --- Sim 32/38: [BAD_74] TT, V=0.95V, T=65.0C | ML=(31,31) vs GT=(60,31) ---
printf("\n>>> [JOB 1: TT] Sim 32/38: BAD_74 (TT) V=0.95V, T=65.0C | ML=(31,31) GT=(60,31) <<<\n")
desVar("tem" 65.0)
desVar("vreg" 0.95)
temp(65.0)
desVar("pvt0" 1)
desVar("pvt1" 1)
desVar("pvt2" 1)
desVar("pvt3" 1)
desVar("pvt4" 1)
desVar("pvt5" 0)
desVar("pvt6" 0)
desVar("pvt7" 0)
desVar("pvt8" 0)
desVar("pvt9" 0)
desVar("pvt10" 0)
desVar("pvt11" 0)
desVar("pvt12" 0)
desVar("pvt13" 0)
desVar("pvtn0" 1)
desVar("pvtn1" 1)
desVar("pvtn2" 1)
desVar("pvtn3" 1)
desVar("pvtn4" 1)
desVar("pvtn5" 0)
desVar("pvtn6" 0)
desVar("pvtn7" 0)
desVar("pvtn8" 0)
desVar("pvtn9" 0)
desVar("pvtn10" 0)
desVar("pvtn11" 0)
desVar("pvtn12" 0)
desVar("pvtn13" 0)
run()
selectResults('tran)
pup_val = average((clip((v("/vdd" ?result "tran") - v("/outn" ?result "tran")) 2e-07 2.5e-07) / clip(i("/xdrv_p/out" ?result "tran") 2e-07 2.5e-07)))
pdn_val = (average((clip(v("/outp" ?result "tran") 2e-07 2.5e-07) / clip(i("/xdrv_p/out" ?result "tran") 2e-07 2.5e-07))) * -1)
fprintf(out_file "BAD_74,TT,0.95,65.0,320876590,60,31,31,31,29,0,%f,%f,49.49,50.43\n" pup_val pdn_val)
drain(out_file)
printf("Result BAD_74 -> pup=%f, pdn=%f (GT Target: pup=49.49, pdn=50.43)\n" pup_val pdn_val)

; --- Sim 33/38: [BAD_75] TT, V=0.97V, T=-7.5C | ML=(30,123) vs GT=(30,30) ---
printf("\n>>> [JOB 1: TT] Sim 33/38: BAD_75 (TT) V=0.97V, T=-7.5C | ML=(30,123) GT=(30,30) <<<\n")
desVar("tem" -7.5)
desVar("vreg" 0.97)
temp(-7.5)
desVar("pvt0" 0)
desVar("pvt1" 1)
desVar("pvt2" 1)
desVar("pvt3" 1)
desVar("pvt4" 1)
desVar("pvt5" 0)
desVar("pvt6" 0)
desVar("pvt7" 0)
desVar("pvt8" 0)
desVar("pvt9" 0)
desVar("pvt10" 0)
desVar("pvt11" 0)
desVar("pvt12" 0)
desVar("pvt13" 0)
desVar("pvtn0" 1)
desVar("pvtn1" 1)
desVar("pvtn2" 0)
desVar("pvtn3" 1)
desVar("pvtn4" 1)
desVar("pvtn5" 1)
desVar("pvtn6" 1)
desVar("pvtn7" 0)
desVar("pvtn8" 0)
desVar("pvtn9" 0)
desVar("pvtn10" 0)
desVar("pvtn11" 0)
desVar("pvtn12" 0)
desVar("pvtn13" 0)
run()
selectResults('tran)
pup_val = average((clip((v("/vdd" ?result "tran") - v("/outn" ?result "tran")) 2e-07 2.5e-07) / clip(i("/xdrv_p/out" ?result "tran") 2e-07 2.5e-07)))
pdn_val = (average((clip(v("/outp" ?result "tran") 2e-07 2.5e-07) / clip(i("/xdrv_p/out" ?result "tran") 2e-07 2.5e-07))) * -1)
fprintf(out_file "BAD_75,TT,0.97,-7.5,358449280,30,30,30,123,0,93,%f,%f,49.83,49.87\n" pup_val pdn_val)
drain(out_file)
printf("Result BAD_75 -> pup=%f, pdn=%f (GT Target: pup=49.83, pdn=49.87)\n" pup_val pdn_val)

; --- Sim 34/38: [BAD_76] TT, V=0.97V, T=-5.0C | ML=(30,123) vs GT=(30,30) ---
printf("\n>>> [JOB 1: TT] Sim 34/38: BAD_76 (TT) V=0.97V, T=-5.0C | ML=(30,123) GT=(30,30) <<<\n")
desVar("tem" -5.0)
desVar("vreg" 0.97)
temp(-5.0)
desVar("pvt0" 0)
desVar("pvt1" 1)
desVar("pvt2" 1)
desVar("pvt3" 1)
desVar("pvt4" 1)
desVar("pvt5" 0)
desVar("pvt6" 0)
desVar("pvt7" 0)
desVar("pvt8" 0)
desVar("pvt9" 0)
desVar("pvt10" 0)
desVar("pvt11" 0)
desVar("pvt12" 0)
desVar("pvt13" 0)
desVar("pvtn0" 1)
desVar("pvtn1" 1)
desVar("pvtn2" 0)
desVar("pvtn3" 1)
desVar("pvtn4" 1)
desVar("pvtn5" 1)
desVar("pvtn6" 1)
desVar("pvtn7" 0)
desVar("pvtn8" 0)
desVar("pvtn9" 0)
desVar("pvtn10" 0)
desVar("pvtn11" 0)
desVar("pvtn12" 0)
desVar("pvtn13" 0)
run()
selectResults('tran)
pup_val = average((clip((v("/vdd" ?result "tran") - v("/outn" ?result "tran")) 2e-07 2.5e-07) / clip(i("/xdrv_p/out" ?result "tran") 2e-07 2.5e-07)))
pdn_val = (average((clip(v("/outp" ?result "tran") 2e-07 2.5e-07) / clip(i("/xdrv_p/out" ?result "tran") 2e-07 2.5e-07))) * -1)
fprintf(out_file "BAD_76,TT,0.97,-5.0,357288710,30,30,30,123,0,93,%f,%f,49.89,49.93\n" pup_val pdn_val)
drain(out_file)
printf("Result BAD_76 -> pup=%f, pdn=%f (GT Target: pup=49.89, pdn=49.93)\n" pup_val pdn_val)

; --- Sim 35/38: [BAD_77] TT, V=0.97V, T=83.5C | ML=(60,60) vs GT=(60,31) ---
printf("\n>>> [JOB 1: TT] Sim 35/38: BAD_77 (TT) V=0.97V, T=83.5C | ML=(60,60) GT=(60,31) <<<\n")
desVar("tem" 83.5)
desVar("vreg" 0.97)
temp(83.5)
desVar("pvt0" 0)
desVar("pvt1" 0)
desVar("pvt2" 1)
desVar("pvt3" 1)
desVar("pvt4" 1)
desVar("pvt5" 1)
desVar("pvt6" 0)
desVar("pvt7" 0)
desVar("pvt8" 0)
desVar("pvt9" 0)
desVar("pvt10" 0)
desVar("pvt11" 0)
desVar("pvt12" 0)
desVar("pvt13" 0)
desVar("pvtn0" 0)
desVar("pvtn1" 0)
desVar("pvtn2" 1)
desVar("pvtn3" 1)
desVar("pvtn4" 1)
desVar("pvtn5" 1)
desVar("pvtn6" 0)
desVar("pvtn7" 0)
desVar("pvtn8" 0)
desVar("pvtn9" 0)
desVar("pvtn10" 0)
desVar("pvtn11" 0)
desVar("pvtn12" 0)
desVar("pvtn13" 0)
run()
selectResults('tran)
pup_val = average((clip((v("/vdd" ?result "tran") - v("/outn" ?result "tran")) 2e-07 2.5e-07) / clip(i("/xdrv_p/out" ?result "tran") 2e-07 2.5e-07)))
pdn_val = (average((clip(v("/outp" ?result "tran") 2e-07 2.5e-07) / clip(i("/xdrv_p/out" ?result "tran") 2e-07 2.5e-07))) * -1)
fprintf(out_file "BAD_77,TT,0.97,83.5,326529150,60,31,60,60,0,29,%f,%f,49.88,50.69\n" pup_val pdn_val)
drain(out_file)
printf("Result BAD_77 -> pup=%f, pdn=%f (GT Target: pup=49.88, pdn=50.69)\n" pup_val pdn_val)

; --- Sim 36/38: [BAD_78] TT, V=0.99V, T=29.0C | ML=(30,123) vs GT=(30,30) ---
printf("\n>>> [JOB 1: TT] Sim 36/38: BAD_78 (TT) V=0.99V, T=29.0C | ML=(30,123) GT=(30,30) <<<\n")
desVar("tem" 29.0)
desVar("vreg" 0.99)
temp(29.0)
desVar("pvt0" 0)
desVar("pvt1" 1)
desVar("pvt2" 1)
desVar("pvt3" 1)
desVar("pvt4" 1)
desVar("pvt5" 0)
desVar("pvt6" 0)
desVar("pvt7" 0)
desVar("pvt8" 0)
desVar("pvt9" 0)
desVar("pvt10" 0)
desVar("pvt11" 0)
desVar("pvt12" 0)
desVar("pvt13" 0)
desVar("pvtn0" 1)
desVar("pvtn1" 1)
desVar("pvtn2" 0)
desVar("pvtn3" 1)
desVar("pvtn4" 1)
desVar("pvtn5" 1)
desVar("pvtn6" 1)
desVar("pvtn7" 0)
desVar("pvtn8" 0)
desVar("pvtn9" 0)
desVar("pvtn10" 0)
desVar("pvtn11" 0)
desVar("pvtn12" 0)
desVar("pvtn13" 0)
run()
selectResults('tran)
pup_val = average((clip((v("/vdd" ?result "tran") - v("/outn" ?result "tran")) 2e-07 2.5e-07) / clip(i("/xdrv_p/out" ?result "tran") 2e-07 2.5e-07)))
pdn_val = (average((clip(v("/outp" ?result "tran") 2e-07 2.5e-07) / clip(i("/xdrv_p/out" ?result "tran") 2e-07 2.5e-07))) * -1)
fprintf(out_file "BAD_78,TT,0.99,29.0,354988510,30,30,30,123,0,93,%f,%f,50.65,50.6\n" pup_val pdn_val)
drain(out_file)
printf("Result BAD_78 -> pup=%f, pdn=%f (GT Target: pup=50.65, pdn=50.6)\n" pup_val pdn_val)

; --- Sim 37/38: [BAD_79] TT, V=0.99V, T=30.5C | ML=(125,30) vs GT=(30,30) ---
printf("\n>>> [JOB 1: TT] Sim 37/38: BAD_79 (TT) V=0.99V, T=30.5C | ML=(125,30) GT=(30,30) <<<\n")
desVar("tem" 30.5)
desVar("vreg" 0.99)
temp(30.5)
desVar("pvt0" 1)
desVar("pvt1" 0)
desVar("pvt2" 1)
desVar("pvt3" 1)
desVar("pvt4" 1)
desVar("pvt5" 1)
desVar("pvt6" 1)
desVar("pvt7" 0)
desVar("pvt8" 0)
desVar("pvt9" 0)
desVar("pvt10" 0)
desVar("pvt11" 0)
desVar("pvt12" 0)
desVar("pvt13" 0)
desVar("pvtn0" 0)
desVar("pvtn1" 1)
desVar("pvtn2" 1)
desVar("pvtn3" 1)
desVar("pvtn4" 1)
desVar("pvtn5" 0)
desVar("pvtn6" 0)
desVar("pvtn7" 0)
desVar("pvtn8" 0)
desVar("pvtn9" 0)
desVar("pvtn10" 0)
desVar("pvtn11" 0)
desVar("pvtn12" 0)
desVar("pvtn13" 0)
run()
selectResults('tran)
pup_val = average((clip((v("/vdd" ?result "tran") - v("/outn" ?result "tran")) 2e-07 2.5e-07) / clip(i("/xdrv_p/out" ?result "tran") 2e-07 2.5e-07)))
pdn_val = (average((clip(v("/outp" ?result "tran") 2e-07 2.5e-07) / clip(i("/xdrv_p/out" ?result "tran") 2e-07 2.5e-07))) * -1)
fprintf(out_file "BAD_79,TT,0.99,30.5,354395760,30,30,125,30,95,0,%f,%f,50.69,50.64\n" pup_val pdn_val)
drain(out_file)
printf("Result BAD_79 -> pup=%f, pdn=%f (GT Target: pup=50.69, pdn=50.64)\n" pup_val pdn_val)

; --- Sim 38/38: [BAD_80] TT, V=0.99V, T=100.0C | ML=(60,14) vs GT=(60,60) ---
printf("\n>>> [JOB 1: TT] Sim 38/38: BAD_80 (TT) V=0.99V, T=100.0C | ML=(60,14) GT=(60,60) <<<\n")
desVar("tem" 100.0)
desVar("vreg" 0.99)
temp(100.0)
desVar("pvt0" 0)
desVar("pvt1" 0)
desVar("pvt2" 1)
desVar("pvt3" 1)
desVar("pvt4" 1)
desVar("pvt5" 1)
desVar("pvt6" 0)
desVar("pvt7" 0)
desVar("pvt8" 0)
desVar("pvt9" 0)
desVar("pvt10" 0)
desVar("pvt11" 0)
desVar("pvt12" 0)
desVar("pvt13" 0)
desVar("pvtn0" 0)
desVar("pvtn1" 1)
desVar("pvtn2" 1)
desVar("pvtn3" 1)
desVar("pvtn4" 0)
desVar("pvtn5" 0)
desVar("pvtn6" 0)
desVar("pvtn7" 0)
desVar("pvtn8" 0)
desVar("pvtn9" 0)
desVar("pvtn10" 0)
desVar("pvtn11" 0)
desVar("pvtn12" 0)
desVar("pvtn13" 0)
run()
selectResults('tran)
pup_val = average((clip((v("/vdd" ?result "tran") - v("/outn" ?result "tran")) 2e-07 2.5e-07) / clip(i("/xdrv_p/out" ?result "tran") 2e-07 2.5e-07)))
pdn_val = (average((clip(v("/outp" ?result "tran") 2e-07 2.5e-07) / clip(i("/xdrv_p/out" ?result "tran") 2e-07 2.5e-07))) * -1)
fprintf(out_file "BAD_80,TT,0.99,100.0,331965890,60,60,60,14,0,46,%f,%f,50.25,49.83\n" pup_val pdn_val)
drain(out_file)
printf("Result BAD_80 -> pup=%f, pdn=%f (GT Target: pup=50.25, pdn=49.83)\n" pup_val pdn_val)

close(out_file)
printf("\n=== JOB 1 (TT) FINISHED! Results in results_job1_TT.csv ===\n")
exit()
