; =============================================================================
; CADENCE SPECTRE OCEAN SCRIPT: JOB 2 - FF_SS (MISMATCH VALIDATION)
; Total Test Cases: 42 | PDK Model: 1.8V (crn28hpcp_1d8_elk...)
; Simulating with ML PREDICTED TRIM to verify 48-52 Ohm Spec Compliance
; Results CSV: results_job2_FF_SS.csv | Results Directory: ./ocean_results_bad_job2
; =============================================================================
simulator('spectre)
design("tsmc28_tx_tb" "tx_drv_ML" "schematic_seriliazer_top")
resultsDir("./ocean_results_bad_job2")
analysis('dc ?saveOppoint t)
analysis('tran ?stop "275n")
envOption('termDirectionMismatch "ignore" 'termMismatch "ignore")
saveOption( ?infoOptions list(list("modelParameter" "models" "rawfile" "" "" "" t) list("element" "inst" "rawfile" "" "" "" t) list("outputParameter" "output" "rawfile" "" "" "" t) list("designParamVals" "parameters" "rawfile" "" "" "" t) list("primitives" "primitives" "rawfile" "" "" "" t) list("subckts" "subckts" "rawfile" "" "" "" t) list("asserts" "assert" "rawfile" "" "" "" nil) list("extremeinfo" "all" "logfile" "" "yes" "" nil) list("allcap" "allcap" "file" "" "" "" nil) list("<Click_To_Add>" "none" "rawfile" "" "" "" nil) ) )
save('i "/xdrv_p/out")

out_file = outfile("results_job2_FF_SS.csv")
fprintf(out_file "test_id,corner,vreg,temp,pmon,gt_pvtp,gt_pvtn,ml_pvtp,ml_pvtn,err_p,err_n,sim_pup,sim_pdn,gt_pup,gt_pdn\n")
drain(out_file)

; --- Set PDK Corner Model for FF ---
modelFile(
    '("/data/cad/pdk_all/pdk_tsmc/pdk_tsmc_28/PDK/TSMC_new_iPDK/models/spectre/crn28hpcp_1d8_elk_v1d0_2p2_shrink0d9_embedded_usage.scs" "ffmacro_mos_moscap")
    '("/data/cad/pdk_all/pdk_tsmc/pdk_tsmc_28/PDK/TSMC_new_iPDK/models/spectre/crn28hpcp_1d8_elk_v1d0_2p2_shrink0d9_embedded_usage.scs" "ff_res_bip_dio_disres")
    '("/data/cad/pdk_all/pdk_tsmc/pdk_tsmc_28/PDK/TSMC_new_iPDK/models/spectre/crn28hpcp_1d8_elk_v1d0_2p2_shrink0d9_embedded_usage.scs" "pre_simu")
)

; --- Sim 1/42: [BAD_01] FF, V=0.81V, T=-23.0C | ML=(14,13) vs GT=(13,13) ---
printf("\n>>> [JOB 2: FF_SS] Sim 1/42: BAD_01 (FF) V=0.81V, T=-23.0C | ML=(14,13) GT=(13,13) <<<\n")
desVar("tem" -23.0)
desVar("vreg" 0.81)
temp(-23.0)
desVar("pvt0" 0)
desVar("pvt1" 1)
desVar("pvt2" 1)
desVar("pvt3" 1)
desVar("pvt4" 0)
desVar("pvt5" 0)
desVar("pvt6" 0)
desVar("pvt7" 0)
desVar("pvt8" 0)
desVar("pvt9" 0)
desVar("pvt10" 0)
desVar("pvt11" 0)
desVar("pvt12" 0)
desVar("pvt13" 0)
desVar("pvtn0" 1)
desVar("pvtn1" 0)
desVar("pvtn2" 1)
desVar("pvtn3" 1)
desVar("pvtn4" 0)
desVar("pvtn5" 0)
desVar("pvtn6" 0)
desVar("pvtn7" 0)
desVar("pvtn8" 0)
desVar("pvtn9" 0)
desVar("pvtn10" 0)
desVar("pvtn11" 0)
desVar("pvtn12" 0)
desVar("pvtn13" 0)
run()
selectResults('tran)
pup_val = average((clip((v("/vdd" ?result "tran") - v("/outn" ?result "tran")) 2e-07 2.5e-07) / clip(i("/xdrv_p/out" ?result "tran") 2e-07 2.5e-07)))
pdn_val = (average((clip(v("/outp" ?result "tran") 2e-07 2.5e-07) / clip(i("/xdrv_p/out" ?result "tran") 2e-07 2.5e-07))) * -1)
fprintf(out_file "BAD_01,FF,0.81,-23.0,286120440,13,13,14,13,1,0,%f,%f,50.69,50.73\n" pup_val pdn_val)
drain(out_file)
printf("Result BAD_01 -> pup=%f, pdn=%f (GT Target: pup=50.69, pdn=50.73)\n" pup_val pdn_val)

; --- Sim 2/42: [BAD_02] FF, V=0.81V, T=-22.5C | ML=(14,13) vs GT=(13,13) ---
printf("\n>>> [JOB 2: FF_SS] Sim 2/42: BAD_02 (FF) V=0.81V, T=-22.5C | ML=(14,13) GT=(13,13) <<<\n")
desVar("tem" -22.5)
desVar("vreg" 0.81)
temp(-22.5)
desVar("pvt0" 0)
desVar("pvt1" 1)
desVar("pvt2" 1)
desVar("pvt3" 1)
desVar("pvt4" 0)
desVar("pvt5" 0)
desVar("pvt6" 0)
desVar("pvt7" 0)
desVar("pvt8" 0)
desVar("pvt9" 0)
desVar("pvt10" 0)
desVar("pvt11" 0)
desVar("pvt12" 0)
desVar("pvt13" 0)
desVar("pvtn0" 1)
desVar("pvtn1" 0)
desVar("pvtn2" 1)
desVar("pvtn3" 1)
desVar("pvtn4" 0)
desVar("pvtn5" 0)
desVar("pvtn6" 0)
desVar("pvtn7" 0)
desVar("pvtn8" 0)
desVar("pvtn9" 0)
desVar("pvtn10" 0)
desVar("pvtn11" 0)
desVar("pvtn12" 0)
desVar("pvtn13" 0)
run()
selectResults('tran)
pup_val = average((clip((v("/vdd" ?result "tran") - v("/outn" ?result "tran")) 2e-07 2.5e-07) / clip(i("/xdrv_p/out" ?result "tran") 2e-07 2.5e-07)))
pdn_val = (average((clip(v("/outp" ?result "tran") 2e-07 2.5e-07) / clip(i("/xdrv_p/out" ?result "tran") 2e-07 2.5e-07))) * -1)
fprintf(out_file "BAD_02,FF,0.81,-22.5,286024720,13,13,14,13,1,0,%f,%f,50.7,50.74\n" pup_val pdn_val)
drain(out_file)
printf("Result BAD_02 -> pup=%f, pdn=%f (GT Target: pup=50.7, pdn=50.74)\n" pup_val pdn_val)

; --- Sim 3/42: [BAD_03] FF, V=0.83V, T=-15.5C | ML=(13,14) vs GT=(13,13) ---
printf("\n>>> [JOB 2: FF_SS] Sim 3/42: BAD_03 (FF) V=0.83V, T=-15.5C | ML=(13,14) GT=(13,13) <<<\n")
desVar("tem" -15.5)
desVar("vreg" 0.83)
temp(-15.5)
desVar("pvt0" 1)
desVar("pvt1" 0)
desVar("pvt2" 1)
desVar("pvt3" 1)
desVar("pvt4" 0)
desVar("pvt5" 0)
desVar("pvt6" 0)
desVar("pvt7" 0)
desVar("pvt8" 0)
desVar("pvt9" 0)
desVar("pvt10" 0)
desVar("pvt11" 0)
desVar("pvt12" 0)
desVar("pvt13" 0)
desVar("pvtn0" 0)
desVar("pvtn1" 1)
desVar("pvtn2" 1)
desVar("pvtn3" 1)
desVar("pvtn4" 0)
desVar("pvtn5" 0)
desVar("pvtn6" 0)
desVar("pvtn7" 0)
desVar("pvtn8" 0)
desVar("pvtn9" 0)
desVar("pvtn10" 0)
desVar("pvtn11" 0)
desVar("pvtn12" 0)
desVar("pvtn13" 0)
run()
selectResults('tran)
pup_val = average((clip((v("/vdd" ?result "tran") - v("/outn" ?result "tran")) 2e-07 2.5e-07) / clip(i("/xdrv_p/out" ?result "tran") 2e-07 2.5e-07)))
pdn_val = (average((clip(v("/outp" ?result "tran") 2e-07 2.5e-07) / clip(i("/xdrv_p/out" ?result "tran") 2e-07 2.5e-07))) * -1)
fprintf(out_file "BAD_03,FF,0.83,-15.5,300582330,13,13,13,14,0,1,%f,%f,50.64,50.7\n" pup_val pdn_val)
drain(out_file)
printf("Result BAD_03 -> pup=%f, pdn=%f (GT Target: pup=50.64, pdn=50.7)\n" pup_val pdn_val)

; --- Sim 4/42: [BAD_04] FF, V=0.83V, T=75.0C | ML=(15,15) vs GT=(28,15) ---
printf("\n>>> [JOB 2: FF_SS] Sim 4/42: BAD_04 (FF) V=0.83V, T=75.0C | ML=(15,15) GT=(28,15) <<<\n")
desVar("tem" 75.0)
desVar("vreg" 0.83)
temp(75.0)
desVar("pvt0" 1)
desVar("pvt1" 1)
desVar("pvt2" 1)
desVar("pvt3" 1)
desVar("pvt4" 0)
desVar("pvt5" 0)
desVar("pvt6" 0)
desVar("pvt7" 0)
desVar("pvt8" 0)
desVar("pvt9" 0)
desVar("pvt10" 0)
desVar("pvt11" 0)
desVar("pvt12" 0)
desVar("pvt13" 0)
desVar("pvtn0" 1)
desVar("pvtn1" 1)
desVar("pvtn2" 1)
desVar("pvtn3" 1)
desVar("pvtn4" 0)
desVar("pvtn5" 0)
desVar("pvtn6" 0)
desVar("pvtn7" 0)
desVar("pvtn8" 0)
desVar("pvtn9" 0)
desVar("pvtn10" 0)
desVar("pvtn11" 0)
desVar("pvtn12" 0)
desVar("pvtn13" 0)
run()
selectResults('tran)
pup_val = average((clip((v("/vdd" ?result "tran") - v("/outn" ?result "tran")) 2e-07 2.5e-07) / clip(i("/xdrv_p/out" ?result "tran") 2e-07 2.5e-07)))
pdn_val = (average((clip(v("/outp" ?result "tran") 2e-07 2.5e-07) / clip(i("/xdrv_p/out" ?result "tran") 2e-07 2.5e-07))) * -1)
fprintf(out_file "BAD_04,FF,0.83,75.0,284657400,28,15,15,15,13,0,%f,%f,49.38,49.79\n" pup_val pdn_val)
drain(out_file)
printf("Result BAD_04 -> pup=%f, pdn=%f (GT Target: pup=49.38, pdn=49.79)\n" pup_val pdn_val)

; --- Sim 5/42: [BAD_05] FF, V=0.83V, T=103.5C | ML=(28,15) vs GT=(29,15) ---
printf("\n>>> [JOB 2: FF_SS] Sim 5/42: BAD_05 (FF) V=0.83V, T=103.5C | ML=(28,15) GT=(29,15) <<<\n")
desVar("tem" 103.5)
desVar("vreg" 0.83)
temp(103.5)
desVar("pvt0" 0)
desVar("pvt1" 0)
desVar("pvt2" 1)
desVar("pvt3" 1)
desVar("pvt4" 1)
desVar("pvt5" 0)
desVar("pvt6" 0)
desVar("pvt7" 0)
desVar("pvt8" 0)
desVar("pvt9" 0)
desVar("pvt10" 0)
desVar("pvt11" 0)
desVar("pvt12" 0)
desVar("pvt13" 0)
desVar("pvtn0" 1)
desVar("pvtn1" 1)
desVar("pvtn2" 1)
desVar("pvtn3" 1)
desVar("pvtn4" 0)
desVar("pvtn5" 0)
desVar("pvtn6" 0)
desVar("pvtn7" 0)
desVar("pvtn8" 0)
desVar("pvtn9" 0)
desVar("pvtn10" 0)
desVar("pvtn11" 0)
desVar("pvtn12" 0)
desVar("pvtn13" 0)
run()
selectResults('tran)
pup_val = average((clip((v("/vdd" ?result "tran") - v("/outn" ?result "tran")) 2e-07 2.5e-07) / clip(i("/xdrv_p/out" ?result "tran") 2e-07 2.5e-07)))
pdn_val = (average((clip(v("/outp" ?result "tran") 2e-07 2.5e-07) / clip(i("/xdrv_p/out" ?result "tran") 2e-07 2.5e-07))) * -1)
fprintf(out_file "BAD_05,FF,0.83,103.5,281757080,29,15,28,15,1,0,%f,%f,49.34,50.4\n" pup_val pdn_val)
drain(out_file)
printf("Result BAD_05 -> pup=%f, pdn=%f (GT Target: pup=49.34, pdn=50.4)\n" pup_val pdn_val)

; --- Sim 6/42: [BAD_06] FF, V=0.85V, T=43.0C | ML=(15,14) vs GT=(14,14) ---
printf("\n>>> [JOB 2: FF_SS] Sim 6/42: BAD_06 (FF) V=0.85V, T=43.0C | ML=(15,14) GT=(14,14) <<<\n")
desVar("tem" 43.0)
desVar("vreg" 0.85)
temp(43.0)
desVar("pvt0" 1)
desVar("pvt1" 1)
desVar("pvt2" 1)
desVar("pvt3" 1)
desVar("pvt4" 0)
desVar("pvt5" 0)
desVar("pvt6" 0)
desVar("pvt7" 0)
desVar("pvt8" 0)
desVar("pvt9" 0)
desVar("pvt10" 0)
desVar("pvt11" 0)
desVar("pvt12" 0)
desVar("pvt13" 0)
desVar("pvtn0" 0)
desVar("pvtn1" 1)
desVar("pvtn2" 1)
desVar("pvtn3" 1)
desVar("pvtn4" 0)
desVar("pvtn5" 0)
desVar("pvtn6" 0)
desVar("pvtn7" 0)
desVar("pvtn8" 0)
desVar("pvtn9" 0)
desVar("pvtn10" 0)
desVar("pvtn11" 0)
desVar("pvtn12" 0)
desVar("pvtn13" 0)
run()
selectResults('tran)
pup_val = average((clip((v("/vdd" ?result "tran") - v("/outn" ?result "tran")) 2e-07 2.5e-07) / clip(i("/xdrv_p/out" ?result "tran") 2e-07 2.5e-07)))
pdn_val = (average((clip(v("/outp" ?result "tran") 2e-07 2.5e-07) / clip(i("/xdrv_p/out" ?result "tran") 2e-07 2.5e-07))) * -1)
fprintf(out_file "BAD_06,FF,0.85,43.0,302035570,14,14,15,14,1,0,%f,%f,50.7,50.26\n" pup_val pdn_val)
drain(out_file)
printf("Result BAD_06 -> pup=%f, pdn=%f (GT Target: pup=50.7, pdn=50.26)\n" pup_val pdn_val)

; --- Sim 7/42: [BAD_07] FF, V=0.85V, T=62.0C | ML=(15,15) vs GT=(15,14) ---
printf("\n>>> [JOB 2: FF_SS] Sim 7/42: BAD_07 (FF) V=0.85V, T=62.0C | ML=(15,15) GT=(15,14) <<<\n")
desVar("tem" 62.0)
desVar("vreg" 0.85)
temp(62.0)
desVar("pvt0" 1)
desVar("pvt1" 1)
desVar("pvt2" 1)
desVar("pvt3" 1)
desVar("pvt4" 0)
desVar("pvt5" 0)
desVar("pvt6" 0)
desVar("pvt7" 0)
desVar("pvt8" 0)
desVar("pvt9" 0)
desVar("pvt10" 0)
desVar("pvt11" 0)
desVar("pvt12" 0)
desVar("pvt13" 0)
desVar("pvtn0" 1)
desVar("pvtn1" 1)
desVar("pvtn2" 1)
desVar("pvtn3" 1)
desVar("pvtn4" 0)
desVar("pvtn5" 0)
desVar("pvtn6" 0)
desVar("pvtn7" 0)
desVar("pvtn8" 0)
desVar("pvtn9" 0)
desVar("pvtn10" 0)
desVar("pvtn11" 0)
desVar("pvtn12" 0)
desVar("pvtn13" 0)
run()
selectResults('tran)
pup_val = average((clip((v("/vdd" ?result "tran") - v("/outn" ?result "tran")) 2e-07 2.5e-07) / clip(i("/xdrv_p/out" ?result "tran") 2e-07 2.5e-07)))
pdn_val = (average((clip(v("/outp" ?result "tran") 2e-07 2.5e-07) / clip(i("/xdrv_p/out" ?result "tran") 2e-07 2.5e-07))) * -1)
fprintf(out_file "BAD_07,FF,0.85,62.0,298650990,15,14,15,15,0,1,%f,%f,49.96,50.69\n" pup_val pdn_val)
drain(out_file)
printf("Result BAD_07 -> pup=%f, pdn=%f (GT Target: pup=49.96, pdn=50.69)\n" pup_val pdn_val)

; --- Sim 8/42: [BAD_08] FF, V=0.85V, T=108.0C | ML=(28,15) vs GT=(29,15) ---
printf("\n>>> [JOB 2: FF_SS] Sim 8/42: BAD_08 (FF) V=0.85V, T=108.0C | ML=(28,15) GT=(29,15) <<<\n")
desVar("tem" 108.0)
desVar("vreg" 0.85)
temp(108.0)
desVar("pvt0" 0)
desVar("pvt1" 0)
desVar("pvt2" 1)
desVar("pvt3" 1)
desVar("pvt4" 1)
desVar("pvt5" 0)
desVar("pvt6" 0)
desVar("pvt7" 0)
desVar("pvt8" 0)
desVar("pvt9" 0)
desVar("pvt10" 0)
desVar("pvt11" 0)
desVar("pvt12" 0)
desVar("pvt13" 0)
desVar("pvtn0" 1)
desVar("pvtn1" 1)
desVar("pvtn2" 1)
desVar("pvtn3" 1)
desVar("pvtn4" 0)
desVar("pvtn5" 0)
desVar("pvtn6" 0)
desVar("pvtn7" 0)
desVar("pvtn8" 0)
desVar("pvtn9" 0)
desVar("pvtn10" 0)
desVar("pvtn11" 0)
desVar("pvtn12" 0)
desVar("pvtn13" 0)
run()
selectResults('tran)
pup_val = average((clip((v("/vdd" ?result "tran") - v("/outn" ?result "tran")) 2e-07 2.5e-07) / clip(i("/xdrv_p/out" ?result "tran") 2e-07 2.5e-07)))
pdn_val = (average((clip(v("/outp" ?result "tran") 2e-07 2.5e-07) / clip(i("/xdrv_p/out" ?result "tran") 2e-07 2.5e-07))) * -1)
fprintf(out_file "BAD_08,FF,0.85,108.0,292321120,29,15,28,15,1,0,%f,%f,49.34,50.32\n" pup_val pdn_val)
drain(out_file)
printf("Result BAD_08 -> pup=%f, pdn=%f (GT Target: pup=49.34, pdn=50.32)\n" pup_val pdn_val)

; --- Sim 9/42: [BAD_09] FF, V=0.87V, T=49.0C | ML=(15,14) vs GT=(14,14) ---
printf("\n>>> [JOB 2: FF_SS] Sim 9/42: BAD_09 (FF) V=0.87V, T=49.0C | ML=(15,14) GT=(14,14) <<<\n")
desVar("tem" 49.0)
desVar("vreg" 0.87)
temp(49.0)
desVar("pvt0" 1)
desVar("pvt1" 1)
desVar("pvt2" 1)
desVar("pvt3" 1)
desVar("pvt4" 0)
desVar("pvt5" 0)
desVar("pvt6" 0)
desVar("pvt7" 0)
desVar("pvt8" 0)
desVar("pvt9" 0)
desVar("pvt10" 0)
desVar("pvt11" 0)
desVar("pvt12" 0)
desVar("pvt13" 0)
desVar("pvtn0" 0)
desVar("pvtn1" 1)
desVar("pvtn2" 1)
desVar("pvtn3" 1)
desVar("pvtn4" 0)
desVar("pvtn5" 0)
desVar("pvtn6" 0)
desVar("pvtn7" 0)
desVar("pvtn8" 0)
desVar("pvtn9" 0)
desVar("pvtn10" 0)
desVar("pvtn11" 0)
desVar("pvtn12" 0)
desVar("pvtn13" 0)
run()
selectResults('tran)
pup_val = average((clip((v("/vdd" ?result "tran") - v("/outn" ?result "tran")) 2e-07 2.5e-07) / clip(i("/xdrv_p/out" ?result "tran") 2e-07 2.5e-07)))
pdn_val = (average((clip(v("/outp" ?result "tran") 2e-07 2.5e-07) / clip(i("/xdrv_p/out" ?result "tran") 2e-07 2.5e-07))) * -1)
fprintf(out_file "BAD_09,FF,0.87,49.0,313587120,14,14,15,14,1,0,%f,%f,50.69,50.22\n" pup_val pdn_val)
drain(out_file)
printf("Result BAD_09 -> pup=%f, pdn=%f (GT Target: pup=50.69, pdn=50.22)\n" pup_val pdn_val)

; --- Sim 10/42: [BAD_10] FF, V=0.87V, T=70.0C | ML=(15,15) vs GT=(15,14) ---
printf("\n>>> [JOB 2: FF_SS] Sim 10/42: BAD_10 (FF) V=0.87V, T=70.0C | ML=(15,15) GT=(15,14) <<<\n")
desVar("tem" 70.0)
desVar("vreg" 0.87)
temp(70.0)
desVar("pvt0" 1)
desVar("pvt1" 1)
desVar("pvt2" 1)
desVar("pvt3" 1)
desVar("pvt4" 0)
desVar("pvt5" 0)
desVar("pvt6" 0)
desVar("pvt7" 0)
desVar("pvt8" 0)
desVar("pvt9" 0)
desVar("pvt10" 0)
desVar("pvt11" 0)
desVar("pvt12" 0)
desVar("pvt13" 0)
desVar("pvtn0" 1)
desVar("pvtn1" 1)
desVar("pvtn2" 1)
desVar("pvtn3" 1)
desVar("pvtn4" 0)
desVar("pvtn5" 0)
desVar("pvtn6" 0)
desVar("pvtn7" 0)
desVar("pvtn8" 0)
desVar("pvtn9" 0)
desVar("pvtn10" 0)
desVar("pvtn11" 0)
desVar("pvtn12" 0)
desVar("pvtn13" 0)
run()
selectResults('tran)
pup_val = average((clip((v("/vdd" ?result "tran") - v("/outn" ?result "tran")) 2e-07 2.5e-07) / clip(i("/xdrv_p/out" ?result "tran") 2e-07 2.5e-07)))
pdn_val = (average((clip(v("/outp" ?result "tran") 2e-07 2.5e-07) / clip(i("/xdrv_p/out" ?result "tran") 2e-07 2.5e-07))) * -1)
fprintf(out_file "BAD_10,FF,0.87,70.0,309310040,15,14,15,15,0,1,%f,%f,50.07,50.7\n" pup_val pdn_val)
drain(out_file)
printf("Result BAD_10 -> pup=%f, pdn=%f (GT Target: pup=50.07, pdn=50.7)\n" pup_val pdn_val)

; --- Sim 11/42: [BAD_11] FF, V=0.87V, T=84.5C | ML=(28,15) vs GT=(15,15) ---
printf("\n>>> [JOB 2: FF_SS] Sim 11/42: BAD_11 (FF) V=0.87V, T=84.5C | ML=(28,15) GT=(15,15) <<<\n")
desVar("tem" 84.5)
desVar("vreg" 0.87)
temp(84.5)
desVar("pvt0" 0)
desVar("pvt1" 0)
desVar("pvt2" 1)
desVar("pvt3" 1)
desVar("pvt4" 1)
desVar("pvt5" 0)
desVar("pvt6" 0)
desVar("pvt7" 0)
desVar("pvt8" 0)
desVar("pvt9" 0)
desVar("pvt10" 0)
desVar("pvt11" 0)
desVar("pvt12" 0)
desVar("pvt13" 0)
desVar("pvtn0" 1)
desVar("pvtn1" 1)
desVar("pvtn2" 1)
desVar("pvtn3" 1)
desVar("pvtn4" 0)
desVar("pvtn5" 0)
desVar("pvtn6" 0)
desVar("pvtn7" 0)
desVar("pvtn8" 0)
desVar("pvtn9" 0)
desVar("pvtn10" 0)
desVar("pvtn11" 0)
desVar("pvtn12" 0)
desVar("pvtn13" 0)
run()
selectResults('tran)
pup_val = average((clip((v("/vdd" ?result "tran") - v("/outn" ?result "tran")) 2e-07 2.5e-07) / clip(i("/xdrv_p/out" ?result "tran") 2e-07 2.5e-07)))
pdn_val = (average((clip(v("/outp" ?result "tran") 2e-07 2.5e-07) / clip(i("/xdrv_p/out" ?result "tran") 2e-07 2.5e-07))) * -1)
fprintf(out_file "BAD_11,FF,0.87,84.5,306707620,15,15,28,15,13,0,%f,%f,50.7,49.64\n" pup_val pdn_val)
drain(out_file)
printf("Result BAD_11 -> pup=%f, pdn=%f (GT Target: pup=50.7, pdn=49.64)\n" pup_val pdn_val)

; --- Sim 12/42: [BAD_12] FF, V=0.87V, T=111.0C | ML=(29,15) vs GT=(28,15) ---
printf("\n>>> [JOB 2: FF_SS] Sim 12/42: BAD_12 (FF) V=0.87V, T=111.0C | ML=(29,15) GT=(28,15) <<<\n")
desVar("tem" 111.0)
desVar("vreg" 0.87)
temp(111.0)
desVar("pvt0" 1)
desVar("pvt1" 0)
desVar("pvt2" 1)
desVar("pvt3" 1)
desVar("pvt4" 1)
desVar("pvt5" 0)
desVar("pvt6" 0)
desVar("pvt7" 0)
desVar("pvt8" 0)
desVar("pvt9" 0)
desVar("pvt10" 0)
desVar("pvt11" 0)
desVar("pvt12" 0)
desVar("pvt13" 0)
desVar("pvtn0" 1)
desVar("pvtn1" 1)
desVar("pvtn2" 1)
desVar("pvtn3" 1)
desVar("pvtn4" 0)
desVar("pvtn5" 0)
desVar("pvtn6" 0)
desVar("pvtn7" 0)
desVar("pvtn8" 0)
desVar("pvtn9" 0)
desVar("pvtn10" 0)
desVar("pvtn11" 0)
desVar("pvtn12" 0)
desVar("pvtn13" 0)
run()
selectResults('tran)
pup_val = average((clip((v("/vdd" ?result "tran") - v("/outn" ?result "tran")) 2e-07 2.5e-07) / clip(i("/xdrv_p/out" ?result "tran") 2e-07 2.5e-07)))
pdn_val = (average((clip(v("/outp" ?result "tran") 2e-07 2.5e-07) / clip(i("/xdrv_p/out" ?result "tran") 2e-07 2.5e-07))) * -1)
fprintf(out_file "BAD_12,FF,0.87,111.0,302553350,28,15,29,15,1,0,%f,%f,50.68,50.21\n" pup_val pdn_val)
drain(out_file)
printf("Result BAD_12 -> pup=%f, pdn=%f (GT Target: pup=50.68, pdn=50.21)\n" pup_val pdn_val)

; --- Sim 13/42: [BAD_13] FF, V=0.89V, T=7.5C | ML=(13,13) vs GT=(13,14) ---
printf("\n>>> [JOB 2: FF_SS] Sim 13/42: BAD_13 (FF) V=0.89V, T=7.5C | ML=(13,13) GT=(13,14) <<<\n")
desVar("tem" 7.5)
desVar("vreg" 0.89)
temp(7.5)
desVar("pvt0" 1)
desVar("pvt1" 0)
desVar("pvt2" 1)
desVar("pvt3" 1)
desVar("pvt4" 0)
desVar("pvt5" 0)
desVar("pvt6" 0)
desVar("pvt7" 0)
desVar("pvt8" 0)
desVar("pvt9" 0)
desVar("pvt10" 0)
desVar("pvt11" 0)
desVar("pvt12" 0)
desVar("pvt13" 0)
desVar("pvtn0" 1)
desVar("pvtn1" 0)
desVar("pvtn2" 1)
desVar("pvtn3" 1)
desVar("pvtn4" 0)
desVar("pvtn5" 0)
desVar("pvtn6" 0)
desVar("pvtn7" 0)
desVar("pvtn8" 0)
desVar("pvtn9" 0)
desVar("pvtn10" 0)
desVar("pvtn11" 0)
desVar("pvtn12" 0)
desVar("pvtn13" 0)
run()
selectResults('tran)
pup_val = average((clip((v("/vdd" ?result "tran") - v("/outn" ?result "tran")) 2e-07 2.5e-07) / clip(i("/xdrv_p/out" ?result "tran") 2e-07 2.5e-07)))
pdn_val = (average((clip(v("/outp" ?result "tran") 2e-07 2.5e-07) / clip(i("/xdrv_p/out" ?result "tran") 2e-07 2.5e-07))) * -1)
fprintf(out_file "BAD_13,FF,0.89,7.5,338388420,13,14,13,13,0,1,%f,%f,50.66,49.12\n" pup_val pdn_val)
drain(out_file)
printf("Result BAD_13 -> pup=%f, pdn=%f (GT Target: pup=50.66, pdn=49.12)\n" pup_val pdn_val)

; --- Sim 14/42: [BAD_14] FF, V=0.89V, T=8.0C | ML=(13,13) vs GT=(13,14) ---
printf("\n>>> [JOB 2: FF_SS] Sim 14/42: BAD_14 (FF) V=0.89V, T=8.0C | ML=(13,13) GT=(13,14) <<<\n")
desVar("tem" 8.0)
desVar("vreg" 0.89)
temp(8.0)
desVar("pvt0" 1)
desVar("pvt1" 0)
desVar("pvt2" 1)
desVar("pvt3" 1)
desVar("pvt4" 0)
desVar("pvt5" 0)
desVar("pvt6" 0)
desVar("pvt7" 0)
desVar("pvt8" 0)
desVar("pvt9" 0)
desVar("pvt10" 0)
desVar("pvt11" 0)
desVar("pvt12" 0)
desVar("pvt13" 0)
desVar("pvtn0" 1)
desVar("pvtn1" 0)
desVar("pvtn2" 1)
desVar("pvtn3" 1)
desVar("pvtn4" 0)
desVar("pvtn5" 0)
desVar("pvtn6" 0)
desVar("pvtn7" 0)
desVar("pvtn8" 0)
desVar("pvtn9" 0)
desVar("pvtn10" 0)
desVar("pvtn11" 0)
desVar("pvtn12" 0)
desVar("pvtn13" 0)
run()
selectResults('tran)
pup_val = average((clip((v("/vdd" ?result "tran") - v("/outn" ?result "tran")) 2e-07 2.5e-07) / clip(i("/xdrv_p/out" ?result "tran") 2e-07 2.5e-07)))
pdn_val = (average((clip(v("/outp" ?result "tran") 2e-07 2.5e-07) / clip(i("/xdrv_p/out" ?result "tran") 2e-07 2.5e-07))) * -1)
fprintf(out_file "BAD_14,FF,0.89,8.0,338236030,13,14,13,13,0,1,%f,%f,50.67,49.13\n" pup_val pdn_val)
drain(out_file)
printf("Result BAD_14 -> pup=%f, pdn=%f (GT Target: pup=50.67, pdn=49.13)\n" pup_val pdn_val)

; --- Sim 15/42: [BAD_15] FF, V=0.91V, T=14.0C | ML=(13,14) vs GT=(13,13) ---
printf("\n>>> [JOB 2: FF_SS] Sim 15/42: BAD_15 (FF) V=0.91V, T=14.0C | ML=(13,14) GT=(13,13) <<<\n")
desVar("tem" 14.0)
desVar("vreg" 0.91)
temp(14.0)
desVar("pvt0" 1)
desVar("pvt1" 0)
desVar("pvt2" 1)
desVar("pvt3" 1)
desVar("pvt4" 0)
desVar("pvt5" 0)
desVar("pvt6" 0)
desVar("pvt7" 0)
desVar("pvt8" 0)
desVar("pvt9" 0)
desVar("pvt10" 0)
desVar("pvt11" 0)
desVar("pvt12" 0)
desVar("pvt13" 0)
desVar("pvtn0" 0)
desVar("pvtn1" 1)
desVar("pvtn2" 1)
desVar("pvtn3" 1)
desVar("pvtn4" 0)
desVar("pvtn5" 0)
desVar("pvtn6" 0)
desVar("pvtn7" 0)
desVar("pvtn8" 0)
desVar("pvtn9" 0)
desVar("pvtn10" 0)
desVar("pvtn11" 0)
desVar("pvtn12" 0)
desVar("pvtn13" 0)
run()
selectResults('tran)
pup_val = average((clip((v("/vdd" ?result "tran") - v("/outn" ?result "tran")) 2e-07 2.5e-07) / clip(i("/xdrv_p/out" ?result "tran") 2e-07 2.5e-07)))
pdn_val = (average((clip(v("/outp" ?result "tran") 2e-07 2.5e-07) / clip(i("/xdrv_p/out" ?result "tran") 2e-07 2.5e-07))) * -1)
fprintf(out_file "BAD_15,FF,0.91,14.0,349731200,13,13,13,14,0,1,%f,%f,50.66,50.7\n" pup_val pdn_val)
drain(out_file)
printf("Result BAD_15 -> pup=%f, pdn=%f (GT Target: pup=50.66, pdn=50.7)\n" pup_val pdn_val)

; --- Sim 16/42: [BAD_16] FF, V=0.93V, T=20.5C | ML=(14,13) vs GT=(13,13) ---
printf("\n>>> [JOB 2: FF_SS] Sim 16/42: BAD_16 (FF) V=0.93V, T=20.5C | ML=(14,13) GT=(13,13) <<<\n")
desVar("tem" 20.5)
desVar("vreg" 0.93)
temp(20.5)
desVar("pvt0" 0)
desVar("pvt1" 1)
desVar("pvt2" 1)
desVar("pvt3" 1)
desVar("pvt4" 0)
desVar("pvt5" 0)
desVar("pvt6" 0)
desVar("pvt7" 0)
desVar("pvt8" 0)
desVar("pvt9" 0)
desVar("pvt10" 0)
desVar("pvt11" 0)
desVar("pvt12" 0)
desVar("pvt13" 0)
desVar("pvtn0" 1)
desVar("pvtn1" 0)
desVar("pvtn2" 1)
desVar("pvtn3" 1)
desVar("pvtn4" 0)
desVar("pvtn5" 0)
desVar("pvtn6" 0)
desVar("pvtn7" 0)
desVar("pvtn8" 0)
desVar("pvtn9" 0)
desVar("pvtn10" 0)
desVar("pvtn11" 0)
desVar("pvtn12" 0)
desVar("pvtn13" 0)
run()
selectResults('tran)
pup_val = average((clip((v("/vdd" ?result "tran") - v("/outn" ?result "tran")) 2e-07 2.5e-07) / clip(i("/xdrv_p/out" ?result "tran") 2e-07 2.5e-07)))
pdn_val = (average((clip(v("/outp" ?result "tran") 2e-07 2.5e-07) / clip(i("/xdrv_p/out" ?result "tran") 2e-07 2.5e-07))) * -1)
fprintf(out_file "BAD_16,FF,0.93,20.5,360400530,13,13,14,13,1,0,%f,%f,50.69,50.71\n" pup_val pdn_val)
drain(out_file)
printf("Result BAD_16 -> pup=%f, pdn=%f (GT Target: pup=50.69, pdn=50.71)\n" pup_val pdn_val)

; --- Sim 17/42: [BAD_17] FF, V=0.93V, T=90.0C | ML=(15,14) vs GT=(15,15) ---
printf("\n>>> [JOB 2: FF_SS] Sim 17/42: BAD_17 (FF) V=0.93V, T=90.0C | ML=(15,14) GT=(15,15) <<<\n")
desVar("tem" 90.0)
desVar("vreg" 0.93)
temp(90.0)
desVar("pvt0" 1)
desVar("pvt1" 1)
desVar("pvt2" 1)
desVar("pvt3" 1)
desVar("pvt4" 0)
desVar("pvt5" 0)
desVar("pvt6" 0)
desVar("pvt7" 0)
desVar("pvt8" 0)
desVar("pvt9" 0)
desVar("pvt10" 0)
desVar("pvt11" 0)
desVar("pvt12" 0)
desVar("pvt13" 0)
desVar("pvtn0" 0)
desVar("pvtn1" 1)
desVar("pvtn2" 1)
desVar("pvtn3" 1)
desVar("pvtn4" 0)
desVar("pvtn5" 0)
desVar("pvtn6" 0)
desVar("pvtn7" 0)
desVar("pvtn8" 0)
desVar("pvtn9" 0)
desVar("pvtn10" 0)
desVar("pvtn11" 0)
desVar("pvtn12" 0)
desVar("pvtn13" 0)
run()
selectResults('tran)
pup_val = average((clip((v("/vdd" ?result "tran") - v("/outn" ?result "tran")) 2e-07 2.5e-07) / clip(i("/xdrv_p/out" ?result "tran") 2e-07 2.5e-07)))
pdn_val = (average((clip(v("/outp" ?result "tran") 2e-07 2.5e-07) / clip(i("/xdrv_p/out" ?result "tran") 2e-07 2.5e-07))) * -1)
fprintf(out_file "BAD_17,FF,0.93,90.0,338336860,15,15,15,14,0,1,%f,%f,50.4,49.33\n" pup_val pdn_val)
drain(out_file)
printf("Result BAD_17 -> pup=%f, pdn=%f (GT Target: pup=50.4, pdn=49.33)\n" pup_val pdn_val)

; --- Sim 18/42: [BAD_18] FF, V=0.95V, T=-36.5C | ML=(12,13) vs GT=(12,12) ---
printf("\n>>> [JOB 2: FF_SS] Sim 18/42: BAD_18 (FF) V=0.95V, T=-36.5C | ML=(12,13) GT=(12,12) <<<\n")
desVar("tem" -36.5)
desVar("vreg" 0.95)
temp(-36.5)
desVar("pvt0" 0)
desVar("pvt1" 0)
desVar("pvt2" 1)
desVar("pvt3" 1)
desVar("pvt4" 0)
desVar("pvt5" 0)
desVar("pvt6" 0)
desVar("pvt7" 0)
desVar("pvt8" 0)
desVar("pvt9" 0)
desVar("pvt10" 0)
desVar("pvt11" 0)
desVar("pvt12" 0)
desVar("pvt13" 0)
desVar("pvtn0" 1)
desVar("pvtn1" 0)
desVar("pvtn2" 1)
desVar("pvtn3" 1)
desVar("pvtn4" 0)
desVar("pvtn5" 0)
desVar("pvtn6" 0)
desVar("pvtn7" 0)
desVar("pvtn8" 0)
desVar("pvtn9" 0)
desVar("pvtn10" 0)
desVar("pvtn11" 0)
desVar("pvtn12" 0)
desVar("pvtn13" 0)
run()
selectResults('tran)
pup_val = average((clip((v("/vdd" ?result "tran") - v("/outn" ?result "tran")) 2e-07 2.5e-07) / clip(i("/xdrv_p/out" ?result "tran") 2e-07 2.5e-07)))
pdn_val = (average((clip(v("/outp" ?result "tran") 2e-07 2.5e-07) / clip(i("/xdrv_p/out" ?result "tran") 2e-07 2.5e-07))) * -1)
fprintf(out_file "BAD_18,FF,0.95,-36.5,403420960,12,12,12,13,0,1,%f,%f,50.47,50.7\n" pup_val pdn_val)
drain(out_file)
printf("Result BAD_18 -> pup=%f, pdn=%f (GT Target: pup=50.47, pdn=50.7)\n" pup_val pdn_val)

; --- Sim 19/42: [BAD_19] FF, V=0.97V, T=-22.5C | ML=(12,13) vs GT=(13,13) ---
printf("\n>>> [JOB 2: FF_SS] Sim 19/42: BAD_19 (FF) V=0.97V, T=-22.5C | ML=(12,13) GT=(13,13) <<<\n")
desVar("tem" -22.5)
desVar("vreg" 0.97)
temp(-22.5)
desVar("pvt0" 0)
desVar("pvt1" 0)
desVar("pvt2" 1)
desVar("pvt3" 1)
desVar("pvt4" 0)
desVar("pvt5" 0)
desVar("pvt6" 0)
desVar("pvt7" 0)
desVar("pvt8" 0)
desVar("pvt9" 0)
desVar("pvt10" 0)
desVar("pvt11" 0)
desVar("pvt12" 0)
desVar("pvt13" 0)
desVar("pvtn0" 1)
desVar("pvtn1" 0)
desVar("pvtn2" 1)
desVar("pvtn3" 1)
desVar("pvtn4" 0)
desVar("pvtn5" 0)
desVar("pvtn6" 0)
desVar("pvtn7" 0)
desVar("pvtn8" 0)
desVar("pvtn9" 0)
desVar("pvtn10" 0)
desVar("pvtn11" 0)
desVar("pvtn12" 0)
desVar("pvtn13" 0)
run()
selectResults('tran)
pup_val = average((clip((v("/vdd" ?result "tran") - v("/outn" ?result "tran")) 2e-07 2.5e-07) / clip(i("/xdrv_p/out" ?result "tran") 2e-07 2.5e-07)))
pdn_val = (average((clip(v("/outp" ?result "tran") 2e-07 2.5e-07) / clip(i("/xdrv_p/out" ?result "tran") 2e-07 2.5e-07))) * -1)
fprintf(out_file "BAD_19,FF,0.97,-22.5,409057240,13,13,12,13,1,0,%f,%f,49.21,49.44\n" pup_val pdn_val)
drain(out_file)
printf("Result BAD_19 -> pup=%f, pdn=%f (GT Target: pup=49.21, pdn=49.44)\n" pup_val pdn_val)

; --- Sim 20/42: [BAD_20] FF, V=0.97V, T=30.0C | ML=(13,13) vs GT=(14,13) ---
printf("\n>>> [JOB 2: FF_SS] Sim 20/42: BAD_20 (FF) V=0.97V, T=30.0C | ML=(13,13) GT=(14,13) <<<\n")
desVar("tem" 30.0)
desVar("vreg" 0.97)
temp(30.0)
desVar("pvt0" 1)
desVar("pvt1" 0)
desVar("pvt2" 1)
desVar("pvt3" 1)
desVar("pvt4" 0)
desVar("pvt5" 0)
desVar("pvt6" 0)
desVar("pvt7" 0)
desVar("pvt8" 0)
desVar("pvt9" 0)
desVar("pvt10" 0)
desVar("pvt11" 0)
desVar("pvt12" 0)
desVar("pvt13" 0)
desVar("pvtn0" 1)
desVar("pvtn1" 0)
desVar("pvtn2" 1)
desVar("pvtn3" 1)
desVar("pvtn4" 0)
desVar("pvtn5" 0)
desVar("pvtn6" 0)
desVar("pvtn7" 0)
desVar("pvtn8" 0)
desVar("pvtn9" 0)
desVar("pvtn10" 0)
desVar("pvtn11" 0)
desVar("pvtn12" 0)
desVar("pvtn13" 0)
run()
selectResults('tran)
pup_val = average((clip((v("/vdd" ?result "tran") - v("/outn" ?result "tran")) 2e-07 2.5e-07) / clip(i("/xdrv_p/out" ?result "tran") 2e-07 2.5e-07)))
pdn_val = (average((clip(v("/outp" ?result "tran") 2e-07 2.5e-07) / clip(i("/xdrv_p/out" ?result "tran") 2e-07 2.5e-07))) * -1)
fprintf(out_file "BAD_20,FF,0.97,30.0,381106610,14,13,13,13,1,0,%f,%f,49.25,50.69\n" pup_val pdn_val)
drain(out_file)
printf("Result BAD_20 -> pup=%f, pdn=%f (GT Target: pup=49.25, pdn=50.69)\n" pup_val pdn_val)

; --- Sim 21/42: [BAD_21] FF, V=0.99V, T=104.5C | ML=(15,14) vs GT=(15,15) ---
printf("\n>>> [JOB 2: FF_SS] Sim 21/42: BAD_21 (FF) V=0.99V, T=104.5C | ML=(15,14) GT=(15,15) <<<\n")
desVar("tem" 104.5)
desVar("vreg" 0.99)
temp(104.5)
desVar("pvt0" 1)
desVar("pvt1" 1)
desVar("pvt2" 1)
desVar("pvt3" 1)
desVar("pvt4" 0)
desVar("pvt5" 0)
desVar("pvt6" 0)
desVar("pvt7" 0)
desVar("pvt8" 0)
desVar("pvt9" 0)
desVar("pvt10" 0)
desVar("pvt11" 0)
desVar("pvt12" 0)
desVar("pvt13" 0)
desVar("pvtn0" 0)
desVar("pvtn1" 1)
desVar("pvtn2" 1)
desVar("pvtn3" 1)
desVar("pvtn4" 0)
desVar("pvtn5" 0)
desVar("pvtn6" 0)
desVar("pvtn7" 0)
desVar("pvtn8" 0)
desVar("pvtn9" 0)
desVar("pvtn10" 0)
desVar("pvtn11" 0)
desVar("pvtn12" 0)
desVar("pvtn13" 0)
run()
selectResults('tran)
pup_val = average((clip((v("/vdd" ?result "tran") - v("/outn" ?result "tran")) 2e-07 2.5e-07) / clip(i("/xdrv_p/out" ?result "tran") 2e-07 2.5e-07)))
pdn_val = (average((clip(v("/outp" ?result "tran") 2e-07 2.5e-07) / clip(i("/xdrv_p/out" ?result "tran") 2e-07 2.5e-07))) * -1)
fprintf(out_file "BAD_21,FF,0.99,104.5,363980920,15,15,15,14,0,1,%f,%f,50.7,49.31\n" pup_val pdn_val)
drain(out_file)
printf("Result BAD_21 -> pup=%f, pdn=%f (GT Target: pup=50.7, pdn=49.31)\n" pup_val pdn_val)

; --- Set PDK Corner Model for SS ---
modelFile(
    '("/data/cad/pdk_all/pdk_tsmc/pdk_tsmc_28/PDK/TSMC_new_iPDK/models/spectre/crn28hpcp_1d8_elk_v1d0_2p2_shrink0d9_embedded_usage.scs" "ssmacro_mos_moscap")
    '("/data/cad/pdk_all/pdk_tsmc/pdk_tsmc_28/PDK/TSMC_new_iPDK/models/spectre/crn28hpcp_1d8_elk_v1d0_2p2_shrink0d9_embedded_usage.scs" "ss_res_bip_dio_disres")
    '("/data/cad/pdk_all/pdk_tsmc/pdk_tsmc_28/PDK/TSMC_new_iPDK/models/spectre/crn28hpcp_1d8_elk_v1d0_2p2_shrink0d9_embedded_usage.scs" "pre_simu")
)

; --- Sim 22/42: [BAD_22] SS, V=0.83V, T=50.0C | ML=(250,250) vs GT=(251,251) ---
printf("\n>>> [JOB 2: FF_SS] Sim 22/42: BAD_22 (SS) V=0.83V, T=50.0C | ML=(250,250) GT=(251,251) <<<\n")
desVar("tem" 50.0)
desVar("vreg" 0.83)
temp(50.0)
desVar("pvt0" 0)
desVar("pvt1" 1)
desVar("pvt2" 0)
desVar("pvt3" 1)
desVar("pvt4" 1)
desVar("pvt5" 1)
desVar("pvt6" 1)
desVar("pvt7" 1)
desVar("pvt8" 0)
desVar("pvt9" 0)
desVar("pvt10" 0)
desVar("pvt11" 0)
desVar("pvt12" 0)
desVar("pvt13" 0)
desVar("pvtn0" 0)
desVar("pvtn1" 1)
desVar("pvtn2" 0)
desVar("pvtn3" 1)
desVar("pvtn4" 1)
desVar("pvtn5" 1)
desVar("pvtn6" 1)
desVar("pvtn7" 1)
desVar("pvtn8" 0)
desVar("pvtn9" 0)
desVar("pvtn10" 0)
desVar("pvtn11" 0)
desVar("pvtn12" 0)
desVar("pvtn13" 0)
run()
selectResults('tran)
pup_val = average((clip((v("/vdd" ?result "tran") - v("/outn" ?result "tran")) 2e-07 2.5e-07) / clip(i("/xdrv_p/out" ?result "tran") 2e-07 2.5e-07)))
pdn_val = (average((clip(v("/outp" ?result "tran") 2e-07 2.5e-07) / clip(i("/xdrv_p/out" ?result "tran") 2e-07 2.5e-07))) * -1)
fprintf(out_file "BAD_22,SS,0.83,50.0,221003350,251,251,250,250,1,1,%f,%f,50.57,49.74\n" pup_val pdn_val)
drain(out_file)
printf("Result BAD_22 -> pup=%f, pdn=%f (GT Target: pup=50.57, pdn=49.74)\n" pup_val pdn_val)

; --- Sim 23/42: [BAD_23] SS, V=0.85V, T=51.5C | ML=(251,250) vs GT=(251,251) ---
printf("\n>>> [JOB 2: FF_SS] Sim 23/42: BAD_23 (SS) V=0.85V, T=51.5C | ML=(251,250) GT=(251,251) <<<\n")
desVar("tem" 51.5)
desVar("vreg" 0.85)
temp(51.5)
desVar("pvt0" 1)
desVar("pvt1" 1)
desVar("pvt2" 0)
desVar("pvt3" 1)
desVar("pvt4" 1)
desVar("pvt5" 1)
desVar("pvt6" 1)
desVar("pvt7" 1)
desVar("pvt8" 0)
desVar("pvt9" 0)
desVar("pvt10" 0)
desVar("pvt11" 0)
desVar("pvt12" 0)
desVar("pvt13" 0)
desVar("pvtn0" 0)
desVar("pvtn1" 1)
desVar("pvtn2" 0)
desVar("pvtn3" 1)
desVar("pvtn4" 1)
desVar("pvtn5" 1)
desVar("pvtn6" 1)
desVar("pvtn7" 1)
desVar("pvtn8" 0)
desVar("pvtn9" 0)
desVar("pvtn10" 0)
desVar("pvtn11" 0)
desVar("pvtn12" 0)
desVar("pvtn13" 0)
run()
selectResults('tran)
pup_val = average((clip((v("/vdd" ?result "tran") - v("/outn" ?result "tran")) 2e-07 2.5e-07) / clip(i("/xdrv_p/out" ?result "tran") 2e-07 2.5e-07)))
pdn_val = (average((clip(v("/outp" ?result "tran") 2e-07 2.5e-07) / clip(i("/xdrv_p/out" ?result "tran") 2e-07 2.5e-07))) * -1)
fprintf(out_file "BAD_23,SS,0.85,51.5,232870150,251,251,251,250,0,1,%f,%f,50.21,49.51\n" pup_val pdn_val)
drain(out_file)
printf("Result BAD_23 -> pup=%f, pdn=%f (GT Target: pup=50.21, pdn=49.51)\n" pup_val pdn_val)

; --- Sim 24/42: [BAD_24] SS, V=0.85V, T=69.0C | ML=(251,251) vs GT=(252,251) ---
printf("\n>>> [JOB 2: FF_SS] Sim 24/42: BAD_24 (SS) V=0.85V, T=69.0C | ML=(251,251) GT=(252,251) <<<\n")
desVar("tem" 69.0)
desVar("vreg" 0.85)
temp(69.0)
desVar("pvt0" 1)
desVar("pvt1" 1)
desVar("pvt2" 0)
desVar("pvt3" 1)
desVar("pvt4" 1)
desVar("pvt5" 1)
desVar("pvt6" 1)
desVar("pvt7" 1)
desVar("pvt8" 0)
desVar("pvt9" 0)
desVar("pvt10" 0)
desVar("pvt11" 0)
desVar("pvt12" 0)
desVar("pvt13" 0)
desVar("pvtn0" 1)
desVar("pvtn1" 1)
desVar("pvtn2" 0)
desVar("pvtn3" 1)
desVar("pvtn4" 1)
desVar("pvtn5" 1)
desVar("pvtn6" 1)
desVar("pvtn7" 1)
desVar("pvtn8" 0)
desVar("pvtn9" 0)
desVar("pvtn10" 0)
desVar("pvtn11" 0)
desVar("pvtn12" 0)
desVar("pvtn13" 0)
run()
selectResults('tran)
pup_val = average((clip((v("/vdd" ?result "tran") - v("/outn" ?result "tran")) 2e-07 2.5e-07) / clip(i("/xdrv_p/out" ?result "tran") 2e-07 2.5e-07)))
pdn_val = (average((clip(v("/outp" ?result "tran") 2e-07 2.5e-07) / clip(i("/xdrv_p/out" ?result "tran") 2e-07 2.5e-07))) * -1)
fprintf(out_file "BAD_24,SS,0.85,69.0,231846040,252,251,251,251,1,0,%f,%f,49.63,49.9\n" pup_val pdn_val)
drain(out_file)
printf("Result BAD_24 -> pup=%f, pdn=%f (GT Target: pup=49.63, pdn=49.9)\n" pup_val pdn_val)

; --- Sim 25/42: [BAD_25] SS, V=0.87V, T=42.5C | ML=(249,249) vs GT=(250,249) ---
printf("\n>>> [JOB 2: FF_SS] Sim 25/42: BAD_25 (SS) V=0.87V, T=42.5C | ML=(249,249) GT=(250,249) <<<\n")
desVar("tem" 42.5)
desVar("vreg" 0.87)
temp(42.5)
desVar("pvt0" 1)
desVar("pvt1" 0)
desVar("pvt2" 0)
desVar("pvt3" 1)
desVar("pvt4" 1)
desVar("pvt5" 1)
desVar("pvt6" 1)
desVar("pvt7" 1)
desVar("pvt8" 0)
desVar("pvt9" 0)
desVar("pvt10" 0)
desVar("pvt11" 0)
desVar("pvt12" 0)
desVar("pvt13" 0)
desVar("pvtn0" 1)
desVar("pvtn1" 0)
desVar("pvtn2" 0)
desVar("pvtn3" 1)
desVar("pvtn4" 1)
desVar("pvtn5" 1)
desVar("pvtn6" 1)
desVar("pvtn7" 1)
desVar("pvtn8" 0)
desVar("pvtn9" 0)
desVar("pvtn10" 0)
desVar("pvtn11" 0)
desVar("pvtn12" 0)
desVar("pvtn13" 0)
run()
selectResults('tran)
pup_val = average((clip((v("/vdd" ?result "tran") - v("/outn" ?result "tran")) 2e-07 2.5e-07) / clip(i("/xdrv_p/out" ?result "tran") 2e-07 2.5e-07)))
pdn_val = (average((clip(v("/outp" ?result "tran") 2e-07 2.5e-07) / clip(i("/xdrv_p/out" ?result "tran") 2e-07 2.5e-07))) * -1)
fprintf(out_file "BAD_25,SS,0.87,42.5,245566740,250,249,249,249,1,0,%f,%f,49.61,50.23\n" pup_val pdn_val)
drain(out_file)
printf("Result BAD_25 -> pup=%f, pdn=%f (GT Target: pup=49.61, pdn=50.23)\n" pup_val pdn_val)

; --- Sim 26/42: [BAD_26] SS, V=0.87V, T=63.0C | ML=(250,249) vs GT=(250,250) ---
printf("\n>>> [JOB 2: FF_SS] Sim 26/42: BAD_26 (SS) V=0.87V, T=63.0C | ML=(250,249) GT=(250,250) <<<\n")
desVar("tem" 63.0)
desVar("vreg" 0.87)
temp(63.0)
desVar("pvt0" 0)
desVar("pvt1" 1)
desVar("pvt2" 0)
desVar("pvt3" 1)
desVar("pvt4" 1)
desVar("pvt5" 1)
desVar("pvt6" 1)
desVar("pvt7" 1)
desVar("pvt8" 0)
desVar("pvt9" 0)
desVar("pvt10" 0)
desVar("pvt11" 0)
desVar("pvt12" 0)
desVar("pvt13" 0)
desVar("pvtn0" 1)
desVar("pvtn1" 0)
desVar("pvtn2" 0)
desVar("pvtn3" 1)
desVar("pvtn4" 1)
desVar("pvtn5" 1)
desVar("pvtn6" 1)
desVar("pvtn7" 1)
desVar("pvtn8" 0)
desVar("pvtn9" 0)
desVar("pvtn10" 0)
desVar("pvtn11" 0)
desVar("pvtn12" 0)
desVar("pvtn13" 0)
run()
selectResults('tran)
pup_val = average((clip((v("/vdd" ?result "tran") - v("/outn" ?result "tran")) 2e-07 2.5e-07) / clip(i("/xdrv_p/out" ?result "tran") 2e-07 2.5e-07)))
pdn_val = (average((clip(v("/outp" ?result "tran") 2e-07 2.5e-07) / clip(i("/xdrv_p/out" ?result "tran") 2e-07 2.5e-07))) * -1)
fprintf(out_file "BAD_26,SS,0.87,63.0,243546040,250,250,250,249,0,1,%f,%f,50.17,49.51\n" pup_val pdn_val)
drain(out_file)
printf("Result BAD_26 -> pup=%f, pdn=%f (GT Target: pup=50.17, pdn=49.51)\n" pup_val pdn_val)

; --- Sim 27/42: [BAD_27] SS, V=0.87V, T=81.5C | ML=(251,250) vs GT=(250,250) ---
printf("\n>>> [JOB 2: FF_SS] Sim 27/42: BAD_27 (SS) V=0.87V, T=81.5C | ML=(251,250) GT=(250,250) <<<\n")
desVar("tem" 81.5)
desVar("vreg" 0.87)
temp(81.5)
desVar("pvt0" 1)
desVar("pvt1" 1)
desVar("pvt2" 0)
desVar("pvt3" 1)
desVar("pvt4" 1)
desVar("pvt5" 1)
desVar("pvt6" 1)
desVar("pvt7" 1)
desVar("pvt8" 0)
desVar("pvt9" 0)
desVar("pvt10" 0)
desVar("pvt11" 0)
desVar("pvt12" 0)
desVar("pvt13" 0)
desVar("pvtn0" 0)
desVar("pvtn1" 1)
desVar("pvtn2" 0)
desVar("pvtn3" 1)
desVar("pvtn4" 1)
desVar("pvtn5" 1)
desVar("pvtn6" 1)
desVar("pvtn7" 1)
desVar("pvtn8" 0)
desVar("pvtn9" 0)
desVar("pvtn10" 0)
desVar("pvtn11" 0)
desVar("pvtn12" 0)
desVar("pvtn13" 0)
run()
selectResults('tran)
pup_val = average((clip((v("/vdd" ?result "tran") - v("/outn" ?result "tran")) 2e-07 2.5e-07) / clip(i("/xdrv_p/out" ?result "tran") 2e-07 2.5e-07)))
pdn_val = (average((clip(v("/outp" ?result "tran") 2e-07 2.5e-07) / clip(i("/xdrv_p/out" ?result "tran") 2e-07 2.5e-07))) * -1)
fprintf(out_file "BAD_27,SS,0.87,81.5,242051110,250,250,251,250,1,0,%f,%f,50.69,49.92\n" pup_val pdn_val)
drain(out_file)
printf("Result BAD_27 -> pup=%f, pdn=%f (GT Target: pup=50.69, pdn=49.92)\n" pup_val pdn_val)

; --- Sim 28/42: [BAD_28] SS, V=0.87V, T=82.0C | ML=(251,250) vs GT=(250,250) ---
printf("\n>>> [JOB 2: FF_SS] Sim 28/42: BAD_28 (SS) V=0.87V, T=82.0C | ML=(251,250) GT=(250,250) <<<\n")
desVar("tem" 82.0)
desVar("vreg" 0.87)
temp(82.0)
desVar("pvt0" 1)
desVar("pvt1" 1)
desVar("pvt2" 0)
desVar("pvt3" 1)
desVar("pvt4" 1)
desVar("pvt5" 1)
desVar("pvt6" 1)
desVar("pvt7" 1)
desVar("pvt8" 0)
desVar("pvt9" 0)
desVar("pvt10" 0)
desVar("pvt11" 0)
desVar("pvt12" 0)
desVar("pvt13" 0)
desVar("pvtn0" 0)
desVar("pvtn1" 1)
desVar("pvtn2" 0)
desVar("pvtn3" 1)
desVar("pvtn4" 1)
desVar("pvtn5" 1)
desVar("pvtn6" 1)
desVar("pvtn7" 1)
desVar("pvtn8" 0)
desVar("pvtn9" 0)
desVar("pvtn10" 0)
desVar("pvtn11" 0)
desVar("pvtn12" 0)
desVar("pvtn13" 0)
run()
selectResults('tran)
pup_val = average((clip((v("/vdd" ?result "tran") - v("/outn" ?result "tran")) 2e-07 2.5e-07) / clip(i("/xdrv_p/out" ?result "tran") 2e-07 2.5e-07)))
pdn_val = (average((clip(v("/outp" ?result "tran") 2e-07 2.5e-07) / clip(i("/xdrv_p/out" ?result "tran") 2e-07 2.5e-07))) * -1)
fprintf(out_file "BAD_28,SS,0.87,82.0,242022100,250,250,251,250,1,0,%f,%f,50.7,49.93\n" pup_val pdn_val)
drain(out_file)
printf("Result BAD_28 -> pup=%f, pdn=%f (GT Target: pup=50.7, pdn=49.93)\n" pup_val pdn_val)

; --- Sim 29/42: [BAD_29] SS, V=0.89V, T=13.0C | ML=(249,248) vs GT=(248,248) ---
printf("\n>>> [JOB 2: FF_SS] Sim 29/42: BAD_29 (SS) V=0.89V, T=13.0C | ML=(249,248) GT=(248,248) <<<\n")
desVar("tem" 13.0)
desVar("vreg" 0.89)
temp(13.0)
desVar("pvt0" 1)
desVar("pvt1" 0)
desVar("pvt2" 0)
desVar("pvt3" 1)
desVar("pvt4" 1)
desVar("pvt5" 1)
desVar("pvt6" 1)
desVar("pvt7" 1)
desVar("pvt8" 0)
desVar("pvt9" 0)
desVar("pvt10" 0)
desVar("pvt11" 0)
desVar("pvt12" 0)
desVar("pvt13" 0)
desVar("pvtn0" 0)
desVar("pvtn1" 0)
desVar("pvtn2" 0)
desVar("pvtn3" 1)
desVar("pvtn4" 1)
desVar("pvtn5" 1)
desVar("pvtn6" 1)
desVar("pvtn7" 1)
desVar("pvtn8" 0)
desVar("pvtn9" 0)
desVar("pvtn10" 0)
desVar("pvtn11" 0)
desVar("pvtn12" 0)
desVar("pvtn13" 0)
run()
selectResults('tran)
pup_val = average((clip((v("/vdd" ?result "tran") - v("/outn" ?result "tran")) 2e-07 2.5e-07) / clip(i("/xdrv_p/out" ?result "tran") 2e-07 2.5e-07)))
pdn_val = (average((clip(v("/outp" ?result "tran") 2e-07 2.5e-07) / clip(i("/xdrv_p/out" ?result "tran") 2e-07 2.5e-07))) * -1)
fprintf(out_file "BAD_29,SS,0.89,13.0,262219940,248,248,249,248,1,0,%f,%f,50.69,50.4\n" pup_val pdn_val)
drain(out_file)
printf("Result BAD_29 -> pup=%f, pdn=%f (GT Target: pup=50.69, pdn=50.4)\n" pup_val pdn_val)

; --- Sim 30/42: [BAD_30] SS, V=0.89V, T=55.5C | ML=(249,249) vs GT=(250,249) ---
printf("\n>>> [JOB 2: FF_SS] Sim 30/42: BAD_30 (SS) V=0.89V, T=55.5C | ML=(249,249) GT=(250,249) <<<\n")
desVar("tem" 55.5)
desVar("vreg" 0.89)
temp(55.5)
desVar("pvt0" 1)
desVar("pvt1" 0)
desVar("pvt2" 0)
desVar("pvt3" 1)
desVar("pvt4" 1)
desVar("pvt5" 1)
desVar("pvt6" 1)
desVar("pvt7" 1)
desVar("pvt8" 0)
desVar("pvt9" 0)
desVar("pvt10" 0)
desVar("pvt11" 0)
desVar("pvt12" 0)
desVar("pvt13" 0)
desVar("pvtn0" 1)
desVar("pvtn1" 0)
desVar("pvtn2" 0)
desVar("pvtn3" 1)
desVar("pvtn4" 1)
desVar("pvtn5" 1)
desVar("pvtn6" 1)
desVar("pvtn7" 1)
desVar("pvtn8" 0)
desVar("pvtn9" 0)
desVar("pvtn10" 0)
desVar("pvtn11" 0)
desVar("pvtn12" 0)
desVar("pvtn13" 0)
run()
selectResults('tran)
pup_val = average((clip((v("/vdd" ?result "tran") - v("/outn" ?result "tran")) 2e-07 2.5e-07) / clip(i("/xdrv_p/out" ?result "tran") 2e-07 2.5e-07)))
pdn_val = (average((clip(v("/outp" ?result "tran") 2e-07 2.5e-07) / clip(i("/xdrv_p/out" ?result "tran") 2e-07 2.5e-07))) * -1)
fprintf(out_file "BAD_30,SS,0.89,55.5,255672920,250,249,249,249,1,0,%f,%f,49.65,50.28\n" pup_val pdn_val)
drain(out_file)
printf("Result BAD_30 -> pup=%f, pdn=%f (GT Target: pup=49.65, pdn=50.28)\n" pup_val pdn_val)

; --- Sim 31/42: [BAD_31] SS, V=0.91V, T=23.5C | ML=(249,248) vs GT=(248,248) ---
printf("\n>>> [JOB 2: FF_SS] Sim 31/42: BAD_31 (SS) V=0.91V, T=23.5C | ML=(249,248) GT=(248,248) <<<\n")
desVar("tem" 23.5)
desVar("vreg" 0.91)
temp(23.5)
desVar("pvt0" 1)
desVar("pvt1" 0)
desVar("pvt2" 0)
desVar("pvt3" 1)
desVar("pvt4" 1)
desVar("pvt5" 1)
desVar("pvt6" 1)
desVar("pvt7" 1)
desVar("pvt8" 0)
desVar("pvt9" 0)
desVar("pvt10" 0)
desVar("pvt11" 0)
desVar("pvt12" 0)
desVar("pvt13" 0)
desVar("pvtn0" 0)
desVar("pvtn1" 0)
desVar("pvtn2" 0)
desVar("pvtn3" 1)
desVar("pvtn4" 1)
desVar("pvtn5" 1)
desVar("pvtn6" 1)
desVar("pvtn7" 1)
desVar("pvtn8" 0)
desVar("pvtn9" 0)
desVar("pvtn10" 0)
desVar("pvtn11" 0)
desVar("pvtn12" 0)
desVar("pvtn13" 0)
run()
selectResults('tran)
pup_val = average((clip((v("/vdd" ?result "tran") - v("/outn" ?result "tran")) 2e-07 2.5e-07) / clip(i("/xdrv_p/out" ?result "tran") 2e-07 2.5e-07)))
pdn_val = (average((clip(v("/outp" ?result "tran") 2e-07 2.5e-07) / clip(i("/xdrv_p/out" ?result "tran") 2e-07 2.5e-07))) * -1)
fprintf(out_file "BAD_31,SS,0.91,23.5,272692910,248,248,249,248,1,0,%f,%f,50.68,50.43\n" pup_val pdn_val)
drain(out_file)
printf("Result BAD_31 -> pup=%f, pdn=%f (GT Target: pup=50.68, pdn=50.43)\n" pup_val pdn_val)

; --- Sim 32/42: [BAD_32] SS, V=0.91V, T=24.0C | ML=(249,248) vs GT=(248,248) ---
printf("\n>>> [JOB 2: FF_SS] Sim 32/42: BAD_32 (SS) V=0.91V, T=24.0C | ML=(249,248) GT=(248,248) <<<\n")
desVar("tem" 24.0)
desVar("vreg" 0.91)
temp(24.0)
desVar("pvt0" 1)
desVar("pvt1" 0)
desVar("pvt2" 0)
desVar("pvt3" 1)
desVar("pvt4" 1)
desVar("pvt5" 1)
desVar("pvt6" 1)
desVar("pvt7" 1)
desVar("pvt8" 0)
desVar("pvt9" 0)
desVar("pvt10" 0)
desVar("pvt11" 0)
desVar("pvt12" 0)
desVar("pvt13" 0)
desVar("pvtn0" 0)
desVar("pvtn1" 0)
desVar("pvtn2" 0)
desVar("pvtn3" 1)
desVar("pvtn4" 1)
desVar("pvtn5" 1)
desVar("pvtn6" 1)
desVar("pvtn7" 1)
desVar("pvtn8" 0)
desVar("pvtn9" 0)
desVar("pvtn10" 0)
desVar("pvtn11" 0)
desVar("pvtn12" 0)
desVar("pvtn13" 0)
run()
selectResults('tran)
pup_val = average((clip((v("/vdd" ?result "tran") - v("/outn" ?result "tran")) 2e-07 2.5e-07) / clip(i("/xdrv_p/out" ?result "tran") 2e-07 2.5e-07)))
pdn_val = (average((clip(v("/outp" ?result "tran") 2e-07 2.5e-07) / clip(i("/xdrv_p/out" ?result "tran") 2e-07 2.5e-07))) * -1)
fprintf(out_file "BAD_32,SS,0.91,24.0,272590830,248,248,249,248,1,0,%f,%f,50.7,50.44\n" pup_val pdn_val)
drain(out_file)
printf("Result BAD_32 -> pup=%f, pdn=%f (GT Target: pup=50.7, pdn=50.44)\n" pup_val pdn_val)

; --- Sim 33/42: [BAD_33] SS, V=0.91V, T=103.5C | ML=(250,250) vs GT=(251,250) ---
printf("\n>>> [JOB 2: FF_SS] Sim 33/42: BAD_33 (SS) V=0.91V, T=103.5C | ML=(250,250) GT=(251,250) <<<\n")
desVar("tem" 103.5)
desVar("vreg" 0.91)
temp(103.5)
desVar("pvt0" 0)
desVar("pvt1" 1)
desVar("pvt2" 0)
desVar("pvt3" 1)
desVar("pvt4" 1)
desVar("pvt5" 1)
desVar("pvt6" 1)
desVar("pvt7" 1)
desVar("pvt8" 0)
desVar("pvt9" 0)
desVar("pvt10" 0)
desVar("pvt11" 0)
desVar("pvt12" 0)
desVar("pvt13" 0)
desVar("pvtn0" 0)
desVar("pvtn1" 1)
desVar("pvtn2" 0)
desVar("pvtn3" 1)
desVar("pvtn4" 1)
desVar("pvtn5" 1)
desVar("pvtn6" 1)
desVar("pvtn7" 1)
desVar("pvtn8" 0)
desVar("pvtn9" 0)
desVar("pvtn10" 0)
desVar("pvtn11" 0)
desVar("pvtn12" 0)
desVar("pvtn13" 0)
run()
selectResults('tran)
pup_val = average((clip((v("/vdd" ?result "tran") - v("/outn" ?result "tran")) 2e-07 2.5e-07) / clip(i("/xdrv_p/out" ?result "tran") 2e-07 2.5e-07)))
pdn_val = (average((clip(v("/outp" ?result "tran") 2e-07 2.5e-07) / clip(i("/xdrv_p/out" ?result "tran") 2e-07 2.5e-07))) * -1)
fprintf(out_file "BAD_33,SS,0.91,103.5,260532300,251,250,250,250,1,0,%f,%f,49.64,49.95\n" pup_val pdn_val)
drain(out_file)
printf("Result BAD_33 -> pup=%f, pdn=%f (GT Target: pup=49.64, pdn=49.95)\n" pup_val pdn_val)

; --- Sim 34/42: [BAD_34] SS, V=0.93V, T=-15.0C | ML=(243,248) vs GT=(243,243) ---
printf("\n>>> [JOB 2: FF_SS] Sim 34/42: BAD_34 (SS) V=0.93V, T=-15.0C | ML=(243,248) GT=(243,243) <<<\n")
desVar("tem" -15.0)
desVar("vreg" 0.93)
temp(-15.0)
desVar("pvt0" 1)
desVar("pvt1" 1)
desVar("pvt2" 0)
desVar("pvt3" 0)
desVar("pvt4" 1)
desVar("pvt5" 1)
desVar("pvt6" 1)
desVar("pvt7" 1)
desVar("pvt8" 0)
desVar("pvt9" 0)
desVar("pvt10" 0)
desVar("pvt11" 0)
desVar("pvt12" 0)
desVar("pvt13" 0)
desVar("pvtn0" 0)
desVar("pvtn1" 0)
desVar("pvtn2" 0)
desVar("pvtn3" 1)
desVar("pvtn4" 1)
desVar("pvtn5" 1)
desVar("pvtn6" 1)
desVar("pvtn7" 1)
desVar("pvtn8" 0)
desVar("pvtn9" 0)
desVar("pvtn10" 0)
desVar("pvtn11" 0)
desVar("pvtn12" 0)
desVar("pvtn13" 0)
run()
selectResults('tran)
pup_val = average((clip((v("/vdd" ?result "tran") - v("/outn" ?result "tran")) 2e-07 2.5e-07) / clip(i("/xdrv_p/out" ?result "tran") 2e-07 2.5e-07)))
pdn_val = (average((clip(v("/outp" ?result "tran") 2e-07 2.5e-07) / clip(i("/xdrv_p/out" ?result "tran") 2e-07 2.5e-07))) * -1)
fprintf(out_file "BAD_34,SS,0.93,-15.0,295537790,243,243,243,248,0,5,%f,%f,50.48,50.29\n" pup_val pdn_val)
drain(out_file)
printf("Result BAD_34 -> pup=%f, pdn=%f (GT Target: pup=50.48, pdn=50.29)\n" pup_val pdn_val)

; --- Sim 35/42: [BAD_35] SS, V=0.93V, T=-14.5C | ML=(248,248) vs GT=(243,243) ---
printf("\n>>> [JOB 2: FF_SS] Sim 35/42: BAD_35 (SS) V=0.93V, T=-14.5C | ML=(248,248) GT=(243,243) <<<\n")
desVar("tem" -14.5)
desVar("vreg" 0.93)
temp(-14.5)
desVar("pvt0" 0)
desVar("pvt1" 0)
desVar("pvt2" 0)
desVar("pvt3" 1)
desVar("pvt4" 1)
desVar("pvt5" 1)
desVar("pvt6" 1)
desVar("pvt7" 1)
desVar("pvt8" 0)
desVar("pvt9" 0)
desVar("pvt10" 0)
desVar("pvt11" 0)
desVar("pvt12" 0)
desVar("pvt13" 0)
desVar("pvtn0" 0)
desVar("pvtn1" 0)
desVar("pvtn2" 0)
desVar("pvtn3" 1)
desVar("pvtn4" 1)
desVar("pvtn5" 1)
desVar("pvtn6" 1)
desVar("pvtn7" 1)
desVar("pvtn8" 0)
desVar("pvtn9" 0)
desVar("pvtn10" 0)
desVar("pvtn11" 0)
desVar("pvtn12" 0)
desVar("pvtn13" 0)
run()
selectResults('tran)
pup_val = average((clip((v("/vdd" ?result "tran") - v("/outn" ?result "tran")) 2e-07 2.5e-07) / clip(i("/xdrv_p/out" ?result "tran") 2e-07 2.5e-07)))
pdn_val = (average((clip(v("/outp" ?result "tran") 2e-07 2.5e-07) / clip(i("/xdrv_p/out" ?result "tran") 2e-07 2.5e-07))) * -1)
fprintf(out_file "BAD_35,SS,0.93,-14.5,295377060,243,243,248,248,5,5,%f,%f,50.5,50.3\n" pup_val pdn_val)
drain(out_file)
printf("Result BAD_35 -> pup=%f, pdn=%f (GT Target: pup=50.5, pdn=50.3)\n" pup_val pdn_val)

; --- Sim 36/42: [BAD_36] SS, V=0.93V, T=40.5C | ML=(249,249) vs GT=(249,248) ---
printf("\n>>> [JOB 2: FF_SS] Sim 36/42: BAD_36 (SS) V=0.93V, T=40.5C | ML=(249,249) GT=(249,248) <<<\n")
desVar("tem" 40.5)
desVar("vreg" 0.93)
temp(40.5)
desVar("pvt0" 1)
desVar("pvt1" 0)
desVar("pvt2" 0)
desVar("pvt3" 1)
desVar("pvt4" 1)
desVar("pvt5" 1)
desVar("pvt6" 1)
desVar("pvt7" 1)
desVar("pvt8" 0)
desVar("pvt9" 0)
desVar("pvt10" 0)
desVar("pvt11" 0)
desVar("pvt12" 0)
desVar("pvt13" 0)
desVar("pvtn0" 1)
desVar("pvtn1" 0)
desVar("pvtn2" 0)
desVar("pvtn3" 1)
desVar("pvtn4" 1)
desVar("pvtn5" 1)
desVar("pvtn6" 1)
desVar("pvtn7" 1)
desVar("pvtn8" 0)
desVar("pvtn9" 0)
desVar("pvtn10" 0)
desVar("pvtn11" 0)
desVar("pvtn12" 0)
desVar("pvtn13" 0)
run()
selectResults('tran)
pup_val = average((clip((v("/vdd" ?result "tran") - v("/outn" ?result "tran")) 2e-07 2.5e-07) / clip(i("/xdrv_p/out" ?result "tran") 2e-07 2.5e-07)))
pdn_val = (average((clip(v("/outp" ?result "tran") 2e-07 2.5e-07) / clip(i("/xdrv_p/out" ?result "tran") 2e-07 2.5e-07))) * -1)
fprintf(out_file "BAD_36,SS,0.93,40.5,280946220,249,248,249,249,0,1,%f,%f,49.76,50.62\n" pup_val pdn_val)
drain(out_file)
printf("Result BAD_36 -> pup=%f, pdn=%f (GT Target: pup=49.76, pdn=50.62)\n" pup_val pdn_val)

; --- Sim 37/42: [BAD_37] SS, V=0.95V, T=1.5C | ML=(122,248) vs GT=(248,248) ---
printf("\n>>> [JOB 2: FF_SS] Sim 37/42: BAD_37 (SS) V=0.95V, T=1.5C | ML=(122,248) GT=(248,248) <<<\n")
desVar("tem" 1.5)
desVar("vreg" 0.95)
temp(1.5)
desVar("pvt0" 0)
desVar("pvt1" 1)
desVar("pvt2" 0)
desVar("pvt3" 1)
desVar("pvt4" 1)
desVar("pvt5" 1)
desVar("pvt6" 1)
desVar("pvt7" 0)
desVar("pvt8" 0)
desVar("pvt9" 0)
desVar("pvt10" 0)
desVar("pvt11" 0)
desVar("pvt12" 0)
desVar("pvt13" 0)
desVar("pvtn0" 0)
desVar("pvtn1" 0)
desVar("pvtn2" 0)
desVar("pvtn3" 1)
desVar("pvtn4" 1)
desVar("pvtn5" 1)
desVar("pvtn6" 1)
desVar("pvtn7" 1)
desVar("pvtn8" 0)
desVar("pvtn9" 0)
desVar("pvtn10" 0)
desVar("pvtn11" 0)
desVar("pvtn12" 0)
desVar("pvtn13" 0)
run()
selectResults('tran)
pup_val = average((clip((v("/vdd" ?result "tran") - v("/outn" ?result "tran")) 2e-07 2.5e-07) / clip(i("/xdrv_p/out" ?result "tran") 2e-07 2.5e-07)))
pdn_val = (average((clip(v("/outp" ?result "tran") 2e-07 2.5e-07) / clip(i("/xdrv_p/out" ?result "tran") 2e-07 2.5e-07))) * -1)
fprintf(out_file "BAD_37,SS,0.95,1.5,303165450,248,248,122,248,126,0,%f,%f,49.58,49.51\n" pup_val pdn_val)
drain(out_file)
printf("Result BAD_37 -> pup=%f, pdn=%f (GT Target: pup=49.58, pdn=49.51)\n" pup_val pdn_val)

; --- Sim 38/42: [BAD_38] SS, V=0.95V, T=51.5C | ML=(249,249) vs GT=(249,248) ---
printf("\n>>> [JOB 2: FF_SS] Sim 38/42: BAD_38 (SS) V=0.95V, T=51.5C | ML=(249,249) GT=(249,248) <<<\n")
desVar("tem" 51.5)
desVar("vreg" 0.95)
temp(51.5)
desVar("pvt0" 1)
desVar("pvt1" 0)
desVar("pvt2" 0)
desVar("pvt3" 1)
desVar("pvt4" 1)
desVar("pvt5" 1)
desVar("pvt6" 1)
desVar("pvt7" 1)
desVar("pvt8" 0)
desVar("pvt9" 0)
desVar("pvt10" 0)
desVar("pvt11" 0)
desVar("pvt12" 0)
desVar("pvt13" 0)
desVar("pvtn0" 1)
desVar("pvtn1" 0)
desVar("pvtn2" 0)
desVar("pvtn3" 1)
desVar("pvtn4" 1)
desVar("pvtn5" 1)
desVar("pvtn6" 1)
desVar("pvtn7" 1)
desVar("pvtn8" 0)
desVar("pvtn9" 0)
desVar("pvtn10" 0)
desVar("pvtn11" 0)
desVar("pvtn12" 0)
desVar("pvtn13" 0)
run()
selectResults('tran)
pup_val = average((clip((v("/vdd" ?result "tran") - v("/outn" ?result "tran")) 2e-07 2.5e-07) / clip(i("/xdrv_p/out" ?result "tran") 2e-07 2.5e-07)))
pdn_val = (average((clip(v("/outp" ?result "tran") 2e-07 2.5e-07) / clip(i("/xdrv_p/out" ?result "tran") 2e-07 2.5e-07))) * -1)
fprintf(out_file "BAD_38,SS,0.95,51.5,289636140,249,248,249,249,0,1,%f,%f,49.84,50.69\n" pup_val pdn_val)
drain(out_file)
printf("Result BAD_38 -> pup=%f, pdn=%f (GT Target: pup=49.84, pdn=50.69)\n" pup_val pdn_val)

; --- Sim 39/42: [BAD_39] SS, V=0.95V, T=83.0C | ML=(249,249) vs GT=(250,249) ---
printf("\n>>> [JOB 2: FF_SS] Sim 39/42: BAD_39 (SS) V=0.95V, T=83.0C | ML=(249,249) GT=(250,249) <<<\n")
desVar("tem" 83.0)
desVar("vreg" 0.95)
temp(83.0)
desVar("pvt0" 1)
desVar("pvt1" 0)
desVar("pvt2" 0)
desVar("pvt3" 1)
desVar("pvt4" 1)
desVar("pvt5" 1)
desVar("pvt6" 1)
desVar("pvt7" 1)
desVar("pvt8" 0)
desVar("pvt9" 0)
desVar("pvt10" 0)
desVar("pvt11" 0)
desVar("pvt12" 0)
desVar("pvt13" 0)
desVar("pvtn0" 1)
desVar("pvtn1" 0)
desVar("pvtn2" 0)
desVar("pvtn3" 1)
desVar("pvtn4" 1)
desVar("pvtn5" 1)
desVar("pvtn6" 1)
desVar("pvtn7" 1)
desVar("pvtn8" 0)
desVar("pvtn9" 0)
desVar("pvtn10" 0)
desVar("pvtn11" 0)
desVar("pvtn12" 0)
desVar("pvtn13" 0)
run()
selectResults('tran)
pup_val = average((clip((v("/vdd" ?result "tran") - v("/outn" ?result "tran")) 2e-07 2.5e-07) / clip(i("/xdrv_p/out" ?result "tran") 2e-07 2.5e-07)))
pdn_val = (average((clip(v("/outp" ?result "tran") 2e-07 2.5e-07) / clip(i("/xdrv_p/out" ?result "tran") 2e-07 2.5e-07))) * -1)
fprintf(out_file "BAD_39,SS,0.95,83.0,283223850,250,249,249,249,1,0,%f,%f,49.61,50.32\n" pup_val pdn_val)
drain(out_file)
printf("Result BAD_39 -> pup=%f, pdn=%f (GT Target: pup=49.61, pdn=50.32)\n" pup_val pdn_val)

; --- Sim 40/42: [BAD_40] SS, V=0.99V, T=-30.5C | ML=(242,123) vs GT=(242,242) ---
printf("\n>>> [JOB 2: FF_SS] Sim 40/42: BAD_40 (SS) V=0.99V, T=-30.5C | ML=(242,123) GT=(242,242) <<<\n")
desVar("tem" -30.5)
desVar("vreg" 0.99)
temp(-30.5)
desVar("pvt0" 0)
desVar("pvt1" 1)
desVar("pvt2" 0)
desVar("pvt3" 0)
desVar("pvt4" 1)
desVar("pvt5" 1)
desVar("pvt6" 1)
desVar("pvt7" 1)
desVar("pvt8" 0)
desVar("pvt9" 0)
desVar("pvt10" 0)
desVar("pvt11" 0)
desVar("pvt12" 0)
desVar("pvt13" 0)
desVar("pvtn0" 1)
desVar("pvtn1" 1)
desVar("pvtn2" 0)
desVar("pvtn3" 1)
desVar("pvtn4" 1)
desVar("pvtn5" 1)
desVar("pvtn6" 1)
desVar("pvtn7" 0)
desVar("pvtn8" 0)
desVar("pvtn9" 0)
desVar("pvtn10" 0)
desVar("pvtn11" 0)
desVar("pvtn12" 0)
desVar("pvtn13" 0)
run()
selectResults('tran)
pup_val = average((clip((v("/vdd" ?result "tran") - v("/outn" ?result "tran")) 2e-07 2.5e-07) / clip(i("/xdrv_p/out" ?result "tran") 2e-07 2.5e-07)))
pdn_val = (average((clip(v("/outp" ?result "tran") 2e-07 2.5e-07) / clip(i("/xdrv_p/out" ?result "tran") 2e-07 2.5e-07))) * -1)
fprintf(out_file "BAD_40,SS,0.99,-30.5,341993810,242,242,242,123,0,119,%f,%f,50.58,50.54\n" pup_val pdn_val)
drain(out_file)
printf("Result BAD_40 -> pup=%f, pdn=%f (GT Target: pup=50.58, pdn=50.54)\n" pup_val pdn_val)

; --- Sim 41/42: [BAD_41] SS, V=0.99V, T=-30.0C | ML=(243,123) vs GT=(242,242) ---
printf("\n>>> [JOB 2: FF_SS] Sim 41/42: BAD_41 (SS) V=0.99V, T=-30.0C | ML=(243,123) GT=(242,242) <<<\n")
desVar("tem" -30.0)
desVar("vreg" 0.99)
temp(-30.0)
desVar("pvt0" 1)
desVar("pvt1" 1)
desVar("pvt2" 0)
desVar("pvt3" 0)
desVar("pvt4" 1)
desVar("pvt5" 1)
desVar("pvt6" 1)
desVar("pvt7" 1)
desVar("pvt8" 0)
desVar("pvt9" 0)
desVar("pvt10" 0)
desVar("pvt11" 0)
desVar("pvt12" 0)
desVar("pvt13" 0)
desVar("pvtn0" 1)
desVar("pvtn1" 1)
desVar("pvtn2" 0)
desVar("pvtn3" 1)
desVar("pvtn4" 1)
desVar("pvtn5" 1)
desVar("pvtn6" 1)
desVar("pvtn7" 0)
desVar("pvtn8" 0)
desVar("pvtn9" 0)
desVar("pvtn10" 0)
desVar("pvtn11" 0)
desVar("pvtn12" 0)
desVar("pvtn13" 0)
run()
selectResults('tran)
pup_val = average((clip((v("/vdd" ?result "tran") - v("/outn" ?result "tran")) 2e-07 2.5e-07) / clip(i("/xdrv_p/out" ?result "tran") 2e-07 2.5e-07)))
pdn_val = (average((clip(v("/outp" ?result "tran") 2e-07 2.5e-07) / clip(i("/xdrv_p/out" ?result "tran") 2e-07 2.5e-07))) * -1)
fprintf(out_file "BAD_41,SS,0.99,-30.0,341749440,242,242,243,123,1,119,%f,%f,50.6,50.56\n" pup_val pdn_val)
drain(out_file)
printf("Result BAD_41 -> pup=%f, pdn=%f (GT Target: pup=50.6, pdn=50.56)\n" pup_val pdn_val)

; --- Sim 42/42: [BAD_42] SS, V=0.99V, T=115.5C | ML=(250,249) vs GT=(250,250) ---
printf("\n>>> [JOB 2: FF_SS] Sim 42/42: BAD_42 (SS) V=0.99V, T=115.5C | ML=(250,249) GT=(250,250) <<<\n")
desVar("tem" 115.5)
desVar("vreg" 0.99)
temp(115.5)
desVar("pvt0" 0)
desVar("pvt1" 1)
desVar("pvt2" 0)
desVar("pvt3" 1)
desVar("pvt4" 1)
desVar("pvt5" 1)
desVar("pvt6" 1)
desVar("pvt7" 1)
desVar("pvt8" 0)
desVar("pvt9" 0)
desVar("pvt10" 0)
desVar("pvt11" 0)
desVar("pvt12" 0)
desVar("pvt13" 0)
desVar("pvtn0" 1)
desVar("pvtn1" 0)
desVar("pvtn2" 0)
desVar("pvtn3" 1)
desVar("pvtn4" 1)
desVar("pvtn5" 1)
desVar("pvtn6" 1)
desVar("pvtn7" 1)
desVar("pvtn8" 0)
desVar("pvtn9" 0)
desVar("pvtn10" 0)
desVar("pvtn11" 0)
desVar("pvtn12" 0)
desVar("pvtn13" 0)
run()
selectResults('tran)
pup_val = average((clip((v("/vdd" ?result "tran") - v("/outn" ?result "tran")) 2e-07 2.5e-07) / clip(i("/xdrv_p/out" ?result "tran") 2e-07 2.5e-07)))
pdn_val = (average((clip(v("/outp" ?result "tran") 2e-07 2.5e-07) / clip(i("/xdrv_p/out" ?result "tran") 2e-07 2.5e-07))) * -1)
fprintf(out_file "BAD_42,SS,0.99,115.5,295704200,250,250,250,249,0,1,%f,%f,50.13,49.51\n" pup_val pdn_val)
drain(out_file)
printf("Result BAD_42 -> pup=%f, pdn=%f (GT Target: pup=50.13, pdn=49.51)\n" pup_val pdn_val)

close(out_file)
printf("\n=== JOB 2 (FF_SS) FINISHED! Results in results_job2_FF_SS.csv ===\n")
exit()
