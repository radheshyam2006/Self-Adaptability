; =============================================================================
; CADENCE SPECTRE OCEAN SCRIPT: JOB3_FF (FF CORNER)
; Total Test Cases: 21 | PDK Model: 1.8V (crn28hpcp_1d8_elk...)
; Simulating with ML PREDICTED TRIM to verify 48-52 Ohm Spec Compliance
; Results CSV: results_job3_FF.csv
; =============================================================================
simulator('spectre)
design("tsmc28_tx_tb" "tx_drv_ML" "schematic_seriliazer_top")
resultsDir("./ocean_results")

; modelFile declared once at top
modelFile(
    '("/data/cad/pdk_all/pdk_tsmc/pdk_tsmc_28/PDK/TSMC_new_iPDK/models/spectre/crn28hpcp_1d8_elk_v1d0_2p2_shrink0d9_embedded_usage.scs" "ffmacro_mos_moscap")
    '("/data/cad/pdk_all/pdk_tsmc/pdk_tsmc_28/PDK/TSMC_new_iPDK/models/spectre/crn28hpcp_1d8_elk_v1d0_2p2_shrink0d9_embedded_usage.scs" "ff_res_bip_dio_disres")
    '("/data/cad/pdk_all/pdk_tsmc/pdk_tsmc_28/PDK/TSMC_new_iPDK/models/spectre/crn28hpcp_1d8_elk_v1d0_2p2_shrink0d9_embedded_usage.scs" "pre_simu")
)

analysis('dc ?saveOppoint t)
analysis('tran ?stop "275n")
envOption('termDirectionMismatch "ignore" 'termMismatch "ignore")
saveOption( ?infoOptions list(list("modelParameter" "models" "rawfile" "" "" "" t) list("element" "inst" "rawfile" "" "" "" t) list("outputParameter" "output" "rawfile" "" "" "" t) list("designParamVals" "parameters" "rawfile" "" "" "" t) list("primitives" "primitives" "rawfile" "" "" "" t) list("subckts" "subckts" "rawfile" "" "" "" t) list("asserts" "assert" "rawfile" "" "" "" nil) list("extremeinfo" "all" "logfile" "" "yes" "" nil) list("allcap" "allcap" "file" "" "" "" nil) list("<Click_To_Add>" "none" "rawfile" "" "" "" nil) ) )
save('i "/xdrv_p/out")

out_file = outfile("results_job3_FF.csv")
fprintf(out_file "test_id,corner,vreg,temp,pmon,gt_pvtp,gt_pvtn,ml_pvtp,ml_pvtn,err_p,err_n,sim_pup,sim_pdn,gt_pup,gt_pdn\n")
drain(out_file)

; --- Sim 1/21: [BAD_01] FF, V=0.81V, T=-23.0C | ML=(14,13) GT=(13,13) ---
printf("\n>>> [job3_FF] Sim 1/21: BAD_01 (FF) V=0.81V, T=-23.0C | ML=(14,13) <<<\n")
desVar("tem" -23.0)
desVar("vreg" 0.81)
temp(-23.0)
desVar("pvt0" 0)
desVar("pvt1" 1)
desVar("pvt2" 1)
desVar("pvt3" 1)
desVar("pvt4" 0)
desVar("pvt5" 0)
desVar("pvt6" 0)
desVar("pvt7" 0)
desVar("pvt8" 0)
desVar("pvt9" 0)
desVar("pvt10" 0)
desVar("pvt11" 0)
desVar("pvt12" 0)
desVar("pvt13" 0)
desVar("pvtn0" 1)
desVar("pvtn1" 0)
desVar("pvtn2" 1)
desVar("pvtn3" 1)
desVar("pvtn4" 0)
desVar("pvtn5" 0)
desVar("pvtn6" 0)
desVar("pvtn7" 0)
desVar("pvtn8" 0)
desVar("pvtn9" 0)
desVar("pvtn10" 0)
desVar("pvtn11" 0)
desVar("pvtn12" 0)
desVar("pvtn13" 0)
run()
selectResults('tran)
pup_val = average((clip((v("/vdd" ?result "tran") - v("/outn" ?result "tran")) 2e-07 2.5e-07) / clip(i("/xdrv_p/out" ?result "tran") 2e-07 2.5e-07)))
pdn_val = (average((clip(v("/outp" ?result "tran") 2e-07 2.5e-07) / clip(i("/xdrv_p/out" ?result "tran") 2e-07 2.5e-07))) * -1)
fprintf(out_file "BAD_01,FF,0.81,-23.0,286120440,13,13,14,13,1,0,%f,%f,50.69,50.73\n" pup_val pdn_val)
drain(out_file)
printf("Result BAD_01 -> pup=%f, pdn=%f (GT Target: pup=50.69, pdn=50.73)\n" pup_val pdn_val)

; --- Sim 2/21: [BAD_02] FF, V=0.81V, T=-22.5C | ML=(14,13) GT=(13,13) ---
printf("\n>>> [job3_FF] Sim 2/21: BAD_02 (FF) V=0.81V, T=-22.5C | ML=(14,13) <<<\n")
desVar("tem" -22.5)
desVar("vreg" 0.81)
temp(-22.5)
desVar("pvt0" 0)
desVar("pvt1" 1)
desVar("pvt2" 1)
desVar("pvt3" 1)
desVar("pvt4" 0)
desVar("pvt5" 0)
desVar("pvt6" 0)
desVar("pvt7" 0)
desVar("pvt8" 0)
desVar("pvt9" 0)
desVar("pvt10" 0)
desVar("pvt11" 0)
desVar("pvt12" 0)
desVar("pvt13" 0)
desVar("pvtn0" 1)
desVar("pvtn1" 0)
desVar("pvtn2" 1)
desVar("pvtn3" 1)
desVar("pvtn4" 0)
desVar("pvtn5" 0)
desVar("pvtn6" 0)
desVar("pvtn7" 0)
desVar("pvtn8" 0)
desVar("pvtn9" 0)
desVar("pvtn10" 0)
desVar("pvtn11" 0)
desVar("pvtn12" 0)
desVar("pvtn13" 0)
run()
selectResults('tran)
pup_val = average((clip((v("/vdd" ?result "tran") - v("/outn" ?result "tran")) 2e-07 2.5e-07) / clip(i("/xdrv_p/out" ?result "tran") 2e-07 2.5e-07)))
pdn_val = (average((clip(v("/outp" ?result "tran") 2e-07 2.5e-07) / clip(i("/xdrv_p/out" ?result "tran") 2e-07 2.5e-07))) * -1)
fprintf(out_file "BAD_02,FF,0.81,-22.5,286024720,13,13,14,13,1,0,%f,%f,50.7,50.74\n" pup_val pdn_val)
drain(out_file)
printf("Result BAD_02 -> pup=%f, pdn=%f (GT Target: pup=50.7, pdn=50.74)\n" pup_val pdn_val)

; --- Sim 3/21: [BAD_03] FF, V=0.83V, T=-15.5C | ML=(13,14) GT=(13,13) ---
printf("\n>>> [job3_FF] Sim 3/21: BAD_03 (FF) V=0.83V, T=-15.5C | ML=(13,14) <<<\n")
desVar("tem" -15.5)
desVar("vreg" 0.83)
temp(-15.5)
desVar("pvt0" 1)
desVar("pvt1" 0)
desVar("pvt2" 1)
desVar("pvt3" 1)
desVar("pvt4" 0)
desVar("pvt5" 0)
desVar("pvt6" 0)
desVar("pvt7" 0)
desVar("pvt8" 0)
desVar("pvt9" 0)
desVar("pvt10" 0)
desVar("pvt11" 0)
desVar("pvt12" 0)
desVar("pvt13" 0)
desVar("pvtn0" 0)
desVar("pvtn1" 1)
desVar("pvtn2" 1)
desVar("pvtn3" 1)
desVar("pvtn4" 0)
desVar("pvtn5" 0)
desVar("pvtn6" 0)
desVar("pvtn7" 0)
desVar("pvtn8" 0)
desVar("pvtn9" 0)
desVar("pvtn10" 0)
desVar("pvtn11" 0)
desVar("pvtn12" 0)
desVar("pvtn13" 0)
run()
selectResults('tran)
pup_val = average((clip((v("/vdd" ?result "tran") - v("/outn" ?result "tran")) 2e-07 2.5e-07) / clip(i("/xdrv_p/out" ?result "tran") 2e-07 2.5e-07)))
pdn_val = (average((clip(v("/outp" ?result "tran") 2e-07 2.5e-07) / clip(i("/xdrv_p/out" ?result "tran") 2e-07 2.5e-07))) * -1)
fprintf(out_file "BAD_03,FF,0.83,-15.5,300582330,13,13,13,14,0,1,%f,%f,50.64,50.7\n" pup_val pdn_val)
drain(out_file)
printf("Result BAD_03 -> pup=%f, pdn=%f (GT Target: pup=50.64, pdn=50.7)\n" pup_val pdn_val)

; --- Sim 4/21: [BAD_04] FF, V=0.83V, T=75.0C | ML=(15,15) GT=(28,15) ---
printf("\n>>> [job3_FF] Sim 4/21: BAD_04 (FF) V=0.83V, T=75.0C | ML=(15,15) <<<\n")
desVar("tem" 75.0)
desVar("vreg" 0.83)
temp(75.0)
desVar("pvt0" 1)
desVar("pvt1" 1)
desVar("pvt2" 1)
desVar("pvt3" 1)
desVar("pvt4" 0)
desVar("pvt5" 0)
desVar("pvt6" 0)
desVar("pvt7" 0)
desVar("pvt8" 0)
desVar("pvt9" 0)
desVar("pvt10" 0)
desVar("pvt11" 0)
desVar("pvt12" 0)
desVar("pvt13" 0)
desVar("pvtn0" 1)
desVar("pvtn1" 1)
desVar("pvtn2" 1)
desVar("pvtn3" 1)
desVar("pvtn4" 0)
desVar("pvtn5" 0)
desVar("pvtn6" 0)
desVar("pvtn7" 0)
desVar("pvtn8" 0)
desVar("pvtn9" 0)
desVar("pvtn10" 0)
desVar("pvtn11" 0)
desVar("pvtn12" 0)
desVar("pvtn13" 0)
run()
selectResults('tran)
pup_val = average((clip((v("/vdd" ?result "tran") - v("/outn" ?result "tran")) 2e-07 2.5e-07) / clip(i("/xdrv_p/out" ?result "tran") 2e-07 2.5e-07)))
pdn_val = (average((clip(v("/outp" ?result "tran") 2e-07 2.5e-07) / clip(i("/xdrv_p/out" ?result "tran") 2e-07 2.5e-07))) * -1)
fprintf(out_file "BAD_04,FF,0.83,75.0,284657400,28,15,15,15,13,0,%f,%f,49.38,49.79\n" pup_val pdn_val)
drain(out_file)
printf("Result BAD_04 -> pup=%f, pdn=%f (GT Target: pup=49.38, pdn=49.79)\n" pup_val pdn_val)

; --- Sim 5/21: [BAD_05] FF, V=0.83V, T=103.5C | ML=(28,15) GT=(29,15) ---
printf("\n>>> [job3_FF] Sim 5/21: BAD_05 (FF) V=0.83V, T=103.5C | ML=(28,15) <<<\n")
desVar("tem" 103.5)
desVar("vreg" 0.83)
temp(103.5)
desVar("pvt0" 0)
desVar("pvt1" 0)
desVar("pvt2" 1)
desVar("pvt3" 1)
desVar("pvt4" 1)
desVar("pvt5" 0)
desVar("pvt6" 0)
desVar("pvt7" 0)
desVar("pvt8" 0)
desVar("pvt9" 0)
desVar("pvt10" 0)
desVar("pvt11" 0)
desVar("pvt12" 0)
desVar("pvt13" 0)
desVar("pvtn0" 1)
desVar("pvtn1" 1)
desVar("pvtn2" 1)
desVar("pvtn3" 1)
desVar("pvtn4" 0)
desVar("pvtn5" 0)
desVar("pvtn6" 0)
desVar("pvtn7" 0)
desVar("pvtn8" 0)
desVar("pvtn9" 0)
desVar("pvtn10" 0)
desVar("pvtn11" 0)
desVar("pvtn12" 0)
desVar("pvtn13" 0)
run()
selectResults('tran)
pup_val = average((clip((v("/vdd" ?result "tran") - v("/outn" ?result "tran")) 2e-07 2.5e-07) / clip(i("/xdrv_p/out" ?result "tran") 2e-07 2.5e-07)))
pdn_val = (average((clip(v("/outp" ?result "tran") 2e-07 2.5e-07) / clip(i("/xdrv_p/out" ?result "tran") 2e-07 2.5e-07))) * -1)
fprintf(out_file "BAD_05,FF,0.83,103.5,281757080,29,15,28,15,1,0,%f,%f,49.34,50.4\n" pup_val pdn_val)
drain(out_file)
printf("Result BAD_05 -> pup=%f, pdn=%f (GT Target: pup=49.34, pdn=50.4)\n" pup_val pdn_val)

; --- Sim 6/21: [BAD_06] FF, V=0.85V, T=43.0C | ML=(15,14) GT=(14,14) ---
printf("\n>>> [job3_FF] Sim 6/21: BAD_06 (FF) V=0.85V, T=43.0C | ML=(15,14) <<<\n")
desVar("tem" 43.0)
desVar("vreg" 0.85)
temp(43.0)
desVar("pvt0" 1)
desVar("pvt1" 1)
desVar("pvt2" 1)
desVar("pvt3" 1)
desVar("pvt4" 0)
desVar("pvt5" 0)
desVar("pvt6" 0)
desVar("pvt7" 0)
desVar("pvt8" 0)
desVar("pvt9" 0)
desVar("pvt10" 0)
desVar("pvt11" 0)
desVar("pvt12" 0)
desVar("pvt13" 0)
desVar("pvtn0" 0)
desVar("pvtn1" 1)
desVar("pvtn2" 1)
desVar("pvtn3" 1)
desVar("pvtn4" 0)
desVar("pvtn5" 0)
desVar("pvtn6" 0)
desVar("pvtn7" 0)
desVar("pvtn8" 0)
desVar("pvtn9" 0)
desVar("pvtn10" 0)
desVar("pvtn11" 0)
desVar("pvtn12" 0)
desVar("pvtn13" 0)
run()
selectResults('tran)
pup_val = average((clip((v("/vdd" ?result "tran") - v("/outn" ?result "tran")) 2e-07 2.5e-07) / clip(i("/xdrv_p/out" ?result "tran") 2e-07 2.5e-07)))
pdn_val = (average((clip(v("/outp" ?result "tran") 2e-07 2.5e-07) / clip(i("/xdrv_p/out" ?result "tran") 2e-07 2.5e-07))) * -1)
fprintf(out_file "BAD_06,FF,0.85,43.0,302035570,14,14,15,14,1,0,%f,%f,50.7,50.26\n" pup_val pdn_val)
drain(out_file)
printf("Result BAD_06 -> pup=%f, pdn=%f (GT Target: pup=50.7, pdn=50.26)\n" pup_val pdn_val)

; --- Sim 7/21: [BAD_07] FF, V=0.85V, T=62.0C | ML=(15,15) GT=(15,14) ---
printf("\n>>> [job3_FF] Sim 7/21: BAD_07 (FF) V=0.85V, T=62.0C | ML=(15,15) <<<\n")
desVar("tem" 62.0)
desVar("vreg" 0.85)
temp(62.0)
desVar("pvt0" 1)
desVar("pvt1" 1)
desVar("pvt2" 1)
desVar("pvt3" 1)
desVar("pvt4" 0)
desVar("pvt5" 0)
desVar("pvt6" 0)
desVar("pvt7" 0)
desVar("pvt8" 0)
desVar("pvt9" 0)
desVar("pvt10" 0)
desVar("pvt11" 0)
desVar("pvt12" 0)
desVar("pvt13" 0)
desVar("pvtn0" 1)
desVar("pvtn1" 1)
desVar("pvtn2" 1)
desVar("pvtn3" 1)
desVar("pvtn4" 0)
desVar("pvtn5" 0)
desVar("pvtn6" 0)
desVar("pvtn7" 0)
desVar("pvtn8" 0)
desVar("pvtn9" 0)
desVar("pvtn10" 0)
desVar("pvtn11" 0)
desVar("pvtn12" 0)
desVar("pvtn13" 0)
run()
selectResults('tran)
pup_val = average((clip((v("/vdd" ?result "tran") - v("/outn" ?result "tran")) 2e-07 2.5e-07) / clip(i("/xdrv_p/out" ?result "tran") 2e-07 2.5e-07)))
pdn_val = (average((clip(v("/outp" ?result "tran") 2e-07 2.5e-07) / clip(i("/xdrv_p/out" ?result "tran") 2e-07 2.5e-07))) * -1)
fprintf(out_file "BAD_07,FF,0.85,62.0,298650990,15,14,15,15,0,1,%f,%f,49.96,50.69\n" pup_val pdn_val)
drain(out_file)
printf("Result BAD_07 -> pup=%f, pdn=%f (GT Target: pup=49.96, pdn=50.69)\n" pup_val pdn_val)

; --- Sim 8/21: [BAD_08] FF, V=0.85V, T=108.0C | ML=(28,15) GT=(29,15) ---
printf("\n>>> [job3_FF] Sim 8/21: BAD_08 (FF) V=0.85V, T=108.0C | ML=(28,15) <<<\n")
desVar("tem" 108.0)
desVar("vreg" 0.85)
temp(108.0)
desVar("pvt0" 0)
desVar("pvt1" 0)
desVar("pvt2" 1)
desVar("pvt3" 1)
desVar("pvt4" 1)
desVar("pvt5" 0)
desVar("pvt6" 0)
desVar("pvt7" 0)
desVar("pvt8" 0)
desVar("pvt9" 0)
desVar("pvt10" 0)
desVar("pvt11" 0)
desVar("pvt12" 0)
desVar("pvt13" 0)
desVar("pvtn0" 1)
desVar("pvtn1" 1)
desVar("pvtn2" 1)
desVar("pvtn3" 1)
desVar("pvtn4" 0)
desVar("pvtn5" 0)
desVar("pvtn6" 0)
desVar("pvtn7" 0)
desVar("pvtn8" 0)
desVar("pvtn9" 0)
desVar("pvtn10" 0)
desVar("pvtn11" 0)
desVar("pvtn12" 0)
desVar("pvtn13" 0)
run()
selectResults('tran)
pup_val = average((clip((v("/vdd" ?result "tran") - v("/outn" ?result "tran")) 2e-07 2.5e-07) / clip(i("/xdrv_p/out" ?result "tran") 2e-07 2.5e-07)))
pdn_val = (average((clip(v("/outp" ?result "tran") 2e-07 2.5e-07) / clip(i("/xdrv_p/out" ?result "tran") 2e-07 2.5e-07))) * -1)
fprintf(out_file "BAD_08,FF,0.85,108.0,292321120,29,15,28,15,1,0,%f,%f,49.34,50.32\n" pup_val pdn_val)
drain(out_file)
printf("Result BAD_08 -> pup=%f, pdn=%f (GT Target: pup=49.34, pdn=50.32)\n" pup_val pdn_val)

; --- Sim 9/21: [BAD_09] FF, V=0.87V, T=49.0C | ML=(15,14) GT=(14,14) ---
printf("\n>>> [job3_FF] Sim 9/21: BAD_09 (FF) V=0.87V, T=49.0C | ML=(15,14) <<<\n")
desVar("tem" 49.0)
desVar("vreg" 0.87)
temp(49.0)
desVar("pvt0" 1)
desVar("pvt1" 1)
desVar("pvt2" 1)
desVar("pvt3" 1)
desVar("pvt4" 0)
desVar("pvt5" 0)
desVar("pvt6" 0)
desVar("pvt7" 0)
desVar("pvt8" 0)
desVar("pvt9" 0)
desVar("pvt10" 0)
desVar("pvt11" 0)
desVar("pvt12" 0)
desVar("pvt13" 0)
desVar("pvtn0" 0)
desVar("pvtn1" 1)
desVar("pvtn2" 1)
desVar("pvtn3" 1)
desVar("pvtn4" 0)
desVar("pvtn5" 0)
desVar("pvtn6" 0)
desVar("pvtn7" 0)
desVar("pvtn8" 0)
desVar("pvtn9" 0)
desVar("pvtn10" 0)
desVar("pvtn11" 0)
desVar("pvtn12" 0)
desVar("pvtn13" 0)
run()
selectResults('tran)
pup_val = average((clip((v("/vdd" ?result "tran") - v("/outn" ?result "tran")) 2e-07 2.5e-07) / clip(i("/xdrv_p/out" ?result "tran") 2e-07 2.5e-07)))
pdn_val = (average((clip(v("/outp" ?result "tran") 2e-07 2.5e-07) / clip(i("/xdrv_p/out" ?result "tran") 2e-07 2.5e-07))) * -1)
fprintf(out_file "BAD_09,FF,0.87,49.0,313587120,14,14,15,14,1,0,%f,%f,50.69,50.22\n" pup_val pdn_val)
drain(out_file)
printf("Result BAD_09 -> pup=%f, pdn=%f (GT Target: pup=50.69, pdn=50.22)\n" pup_val pdn_val)

; --- Sim 10/21: [BAD_10] FF, V=0.87V, T=70.0C | ML=(15,15) GT=(15,14) ---
printf("\n>>> [job3_FF] Sim 10/21: BAD_10 (FF) V=0.87V, T=70.0C | ML=(15,15) <<<\n")
desVar("tem" 70.0)
desVar("vreg" 0.87)
temp(70.0)
desVar("pvt0" 1)
desVar("pvt1" 1)
desVar("pvt2" 1)
desVar("pvt3" 1)
desVar("pvt4" 0)
desVar("pvt5" 0)
desVar("pvt6" 0)
desVar("pvt7" 0)
desVar("pvt8" 0)
desVar("pvt9" 0)
desVar("pvt10" 0)
desVar("pvt11" 0)
desVar("pvt12" 0)
desVar("pvt13" 0)
desVar("pvtn0" 1)
desVar("pvtn1" 1)
desVar("pvtn2" 1)
desVar("pvtn3" 1)
desVar("pvtn4" 0)
desVar("pvtn5" 0)
desVar("pvtn6" 0)
desVar("pvtn7" 0)
desVar("pvtn8" 0)
desVar("pvtn9" 0)
desVar("pvtn10" 0)
desVar("pvtn11" 0)
desVar("pvtn12" 0)
desVar("pvtn13" 0)
run()
selectResults('tran)
pup_val = average((clip((v("/vdd" ?result "tran") - v("/outn" ?result "tran")) 2e-07 2.5e-07) / clip(i("/xdrv_p/out" ?result "tran") 2e-07 2.5e-07)))
pdn_val = (average((clip(v("/outp" ?result "tran") 2e-07 2.5e-07) / clip(i("/xdrv_p/out" ?result "tran") 2e-07 2.5e-07))) * -1)
fprintf(out_file "BAD_10,FF,0.87,70.0,309310040,15,14,15,15,0,1,%f,%f,50.07,50.7\n" pup_val pdn_val)
drain(out_file)
printf("Result BAD_10 -> pup=%f, pdn=%f (GT Target: pup=50.07, pdn=50.7)\n" pup_val pdn_val)

; --- Sim 11/21: [BAD_11] FF, V=0.87V, T=84.5C | ML=(28,15) GT=(15,15) ---
printf("\n>>> [job3_FF] Sim 11/21: BAD_11 (FF) V=0.87V, T=84.5C | ML=(28,15) <<<\n")
desVar("tem" 84.5)
desVar("vreg" 0.87)
temp(84.5)
desVar("pvt0" 0)
desVar("pvt1" 0)
desVar("pvt2" 1)
desVar("pvt3" 1)
desVar("pvt4" 1)
desVar("pvt5" 0)
desVar("pvt6" 0)
desVar("pvt7" 0)
desVar("pvt8" 0)
desVar("pvt9" 0)
desVar("pvt10" 0)
desVar("pvt11" 0)
desVar("pvt12" 0)
desVar("pvt13" 0)
desVar("pvtn0" 1)
desVar("pvtn1" 1)
desVar("pvtn2" 1)
desVar("pvtn3" 1)
desVar("pvtn4" 0)
desVar("pvtn5" 0)
desVar("pvtn6" 0)
desVar("pvtn7" 0)
desVar("pvtn8" 0)
desVar("pvtn9" 0)
desVar("pvtn10" 0)
desVar("pvtn11" 0)
desVar("pvtn12" 0)
desVar("pvtn13" 0)
run()
selectResults('tran)
pup_val = average((clip((v("/vdd" ?result "tran") - v("/outn" ?result "tran")) 2e-07 2.5e-07) / clip(i("/xdrv_p/out" ?result "tran") 2e-07 2.5e-07)))
pdn_val = (average((clip(v("/outp" ?result "tran") 2e-07 2.5e-07) / clip(i("/xdrv_p/out" ?result "tran") 2e-07 2.5e-07))) * -1)
fprintf(out_file "BAD_11,FF,0.87,84.5,306707620,15,15,28,15,13,0,%f,%f,50.7,49.64\n" pup_val pdn_val)
drain(out_file)
printf("Result BAD_11 -> pup=%f, pdn=%f (GT Target: pup=50.7, pdn=49.64)\n" pup_val pdn_val)

; --- Sim 12/21: [BAD_12] FF, V=0.87V, T=111.0C | ML=(29,15) GT=(28,15) ---
printf("\n>>> [job3_FF] Sim 12/21: BAD_12 (FF) V=0.87V, T=111.0C | ML=(29,15) <<<\n")
desVar("tem" 111.0)
desVar("vreg" 0.87)
temp(111.0)
desVar("pvt0" 1)
desVar("pvt1" 0)
desVar("pvt2" 1)
desVar("pvt3" 1)
desVar("pvt4" 1)
desVar("pvt5" 0)
desVar("pvt6" 0)
desVar("pvt7" 0)
desVar("pvt8" 0)
desVar("pvt9" 0)
desVar("pvt10" 0)
desVar("pvt11" 0)
desVar("pvt12" 0)
desVar("pvt13" 0)
desVar("pvtn0" 1)
desVar("pvtn1" 1)
desVar("pvtn2" 1)
desVar("pvtn3" 1)
desVar("pvtn4" 0)
desVar("pvtn5" 0)
desVar("pvtn6" 0)
desVar("pvtn7" 0)
desVar("pvtn8" 0)
desVar("pvtn9" 0)
desVar("pvtn10" 0)
desVar("pvtn11" 0)
desVar("pvtn12" 0)
desVar("pvtn13" 0)
run()
selectResults('tran)
pup_val = average((clip((v("/vdd" ?result "tran") - v("/outn" ?result "tran")) 2e-07 2.5e-07) / clip(i("/xdrv_p/out" ?result "tran") 2e-07 2.5e-07)))
pdn_val = (average((clip(v("/outp" ?result "tran") 2e-07 2.5e-07) / clip(i("/xdrv_p/out" ?result "tran") 2e-07 2.5e-07))) * -1)
fprintf(out_file "BAD_12,FF,0.87,111.0,302553350,28,15,29,15,1,0,%f,%f,50.68,50.21\n" pup_val pdn_val)
drain(out_file)
printf("Result BAD_12 -> pup=%f, pdn=%f (GT Target: pup=50.68, pdn=50.21)\n" pup_val pdn_val)

; --- Sim 13/21: [BAD_13] FF, V=0.89V, T=7.5C | ML=(13,13) GT=(13,14) ---
printf("\n>>> [job3_FF] Sim 13/21: BAD_13 (FF) V=0.89V, T=7.5C | ML=(13,13) <<<\n")
desVar("tem" 7.5)
desVar("vreg" 0.89)
temp(7.5)
desVar("pvt0" 1)
desVar("pvt1" 0)
desVar("pvt2" 1)
desVar("pvt3" 1)
desVar("pvt4" 0)
desVar("pvt5" 0)
desVar("pvt6" 0)
desVar("pvt7" 0)
desVar("pvt8" 0)
desVar("pvt9" 0)
desVar("pvt10" 0)
desVar("pvt11" 0)
desVar("pvt12" 0)
desVar("pvt13" 0)
desVar("pvtn0" 1)
desVar("pvtn1" 0)
desVar("pvtn2" 1)
desVar("pvtn3" 1)
desVar("pvtn4" 0)
desVar("pvtn5" 0)
desVar("pvtn6" 0)
desVar("pvtn7" 0)
desVar("pvtn8" 0)
desVar("pvtn9" 0)
desVar("pvtn10" 0)
desVar("pvtn11" 0)
desVar("pvtn12" 0)
desVar("pvtn13" 0)
run()
selectResults('tran)
pup_val = average((clip((v("/vdd" ?result "tran") - v("/outn" ?result "tran")) 2e-07 2.5e-07) / clip(i("/xdrv_p/out" ?result "tran") 2e-07 2.5e-07)))
pdn_val = (average((clip(v("/outp" ?result "tran") 2e-07 2.5e-07) / clip(i("/xdrv_p/out" ?result "tran") 2e-07 2.5e-07))) * -1)
fprintf(out_file "BAD_13,FF,0.89,7.5,338388420,13,14,13,13,0,1,%f,%f,50.66,49.12\n" pup_val pdn_val)
drain(out_file)
printf("Result BAD_13 -> pup=%f, pdn=%f (GT Target: pup=50.66, pdn=49.12)\n" pup_val pdn_val)

; --- Sim 14/21: [BAD_14] FF, V=0.89V, T=8.0C | ML=(13,13) GT=(13,14) ---
printf("\n>>> [job3_FF] Sim 14/21: BAD_14 (FF) V=0.89V, T=8.0C | ML=(13,13) <<<\n")
desVar("tem" 8.0)
desVar("vreg" 0.89)
temp(8.0)
desVar("pvt0" 1)
desVar("pvt1" 0)
desVar("pvt2" 1)
desVar("pvt3" 1)
desVar("pvt4" 0)
desVar("pvt5" 0)
desVar("pvt6" 0)
desVar("pvt7" 0)
desVar("pvt8" 0)
desVar("pvt9" 0)
desVar("pvt10" 0)
desVar("pvt11" 0)
desVar("pvt12" 0)
desVar("pvt13" 0)
desVar("pvtn0" 1)
desVar("pvtn1" 0)
desVar("pvtn2" 1)
desVar("pvtn3" 1)
desVar("pvtn4" 0)
desVar("pvtn5" 0)
desVar("pvtn6" 0)
desVar("pvtn7" 0)
desVar("pvtn8" 0)
desVar("pvtn9" 0)
desVar("pvtn10" 0)
desVar("pvtn11" 0)
desVar("pvtn12" 0)
desVar("pvtn13" 0)
run()
selectResults('tran)
pup_val = average((clip((v("/vdd" ?result "tran") - v("/outn" ?result "tran")) 2e-07 2.5e-07) / clip(i("/xdrv_p/out" ?result "tran") 2e-07 2.5e-07)))
pdn_val = (average((clip(v("/outp" ?result "tran") 2e-07 2.5e-07) / clip(i("/xdrv_p/out" ?result "tran") 2e-07 2.5e-07))) * -1)
fprintf(out_file "BAD_14,FF,0.89,8.0,338236030,13,14,13,13,0,1,%f,%f,50.67,49.13\n" pup_val pdn_val)
drain(out_file)
printf("Result BAD_14 -> pup=%f, pdn=%f (GT Target: pup=50.67, pdn=49.13)\n" pup_val pdn_val)

; --- Sim 15/21: [BAD_15] FF, V=0.91V, T=14.0C | ML=(13,14) GT=(13,13) ---
printf("\n>>> [job3_FF] Sim 15/21: BAD_15 (FF) V=0.91V, T=14.0C | ML=(13,14) <<<\n")
desVar("tem" 14.0)
desVar("vreg" 0.91)
temp(14.0)
desVar("pvt0" 1)
desVar("pvt1" 0)
desVar("pvt2" 1)
desVar("pvt3" 1)
desVar("pvt4" 0)
desVar("pvt5" 0)
desVar("pvt6" 0)
desVar("pvt7" 0)
desVar("pvt8" 0)
desVar("pvt9" 0)
desVar("pvt10" 0)
desVar("pvt11" 0)
desVar("pvt12" 0)
desVar("pvt13" 0)
desVar("pvtn0" 0)
desVar("pvtn1" 1)
desVar("pvtn2" 1)
desVar("pvtn3" 1)
desVar("pvtn4" 0)
desVar("pvtn5" 0)
desVar("pvtn6" 0)
desVar("pvtn7" 0)
desVar("pvtn8" 0)
desVar("pvtn9" 0)
desVar("pvtn10" 0)
desVar("pvtn11" 0)
desVar("pvtn12" 0)
desVar("pvtn13" 0)
run()
selectResults('tran)
pup_val = average((clip((v("/vdd" ?result "tran") - v("/outn" ?result "tran")) 2e-07 2.5e-07) / clip(i("/xdrv_p/out" ?result "tran") 2e-07 2.5e-07)))
pdn_val = (average((clip(v("/outp" ?result "tran") 2e-07 2.5e-07) / clip(i("/xdrv_p/out" ?result "tran") 2e-07 2.5e-07))) * -1)
fprintf(out_file "BAD_15,FF,0.91,14.0,349731200,13,13,13,14,0,1,%f,%f,50.66,50.7\n" pup_val pdn_val)
drain(out_file)
printf("Result BAD_15 -> pup=%f, pdn=%f (GT Target: pup=50.66, pdn=50.7)\n" pup_val pdn_val)

; --- Sim 16/21: [BAD_16] FF, V=0.93V, T=20.5C | ML=(14,13) GT=(13,13) ---
printf("\n>>> [job3_FF] Sim 16/21: BAD_16 (FF) V=0.93V, T=20.5C | ML=(14,13) <<<\n")
desVar("tem" 20.5)
desVar("vreg" 0.93)
temp(20.5)
desVar("pvt0" 0)
desVar("pvt1" 1)
desVar("pvt2" 1)
desVar("pvt3" 1)
desVar("pvt4" 0)
desVar("pvt5" 0)
desVar("pvt6" 0)
desVar("pvt7" 0)
desVar("pvt8" 0)
desVar("pvt9" 0)
desVar("pvt10" 0)
desVar("pvt11" 0)
desVar("pvt12" 0)
desVar("pvt13" 0)
desVar("pvtn0" 1)
desVar("pvtn1" 0)
desVar("pvtn2" 1)
desVar("pvtn3" 1)
desVar("pvtn4" 0)
desVar("pvtn5" 0)
desVar("pvtn6" 0)
desVar("pvtn7" 0)
desVar("pvtn8" 0)
desVar("pvtn9" 0)
desVar("pvtn10" 0)
desVar("pvtn11" 0)
desVar("pvtn12" 0)
desVar("pvtn13" 0)
run()
selectResults('tran)
pup_val = average((clip((v("/vdd" ?result "tran") - v("/outn" ?result "tran")) 2e-07 2.5e-07) / clip(i("/xdrv_p/out" ?result "tran") 2e-07 2.5e-07)))
pdn_val = (average((clip(v("/outp" ?result "tran") 2e-07 2.5e-07) / clip(i("/xdrv_p/out" ?result "tran") 2e-07 2.5e-07))) * -1)
fprintf(out_file "BAD_16,FF,0.93,20.5,360400530,13,13,14,13,1,0,%f,%f,50.69,50.71\n" pup_val pdn_val)
drain(out_file)
printf("Result BAD_16 -> pup=%f, pdn=%f (GT Target: pup=50.69, pdn=50.71)\n" pup_val pdn_val)

; --- Sim 17/21: [BAD_17] FF, V=0.93V, T=90.0C | ML=(15,14) GT=(15,15) ---
printf("\n>>> [job3_FF] Sim 17/21: BAD_17 (FF) V=0.93V, T=90.0C | ML=(15,14) <<<\n")
desVar("tem" 90.0)
desVar("vreg" 0.93)
temp(90.0)
desVar("pvt0" 1)
desVar("pvt1" 1)
desVar("pvt2" 1)
desVar("pvt3" 1)
desVar("pvt4" 0)
desVar("pvt5" 0)
desVar("pvt6" 0)
desVar("pvt7" 0)
desVar("pvt8" 0)
desVar("pvt9" 0)
desVar("pvt10" 0)
desVar("pvt11" 0)
desVar("pvt12" 0)
desVar("pvt13" 0)
desVar("pvtn0" 0)
desVar("pvtn1" 1)
desVar("pvtn2" 1)
desVar("pvtn3" 1)
desVar("pvtn4" 0)
desVar("pvtn5" 0)
desVar("pvtn6" 0)
desVar("pvtn7" 0)
desVar("pvtn8" 0)
desVar("pvtn9" 0)
desVar("pvtn10" 0)
desVar("pvtn11" 0)
desVar("pvtn12" 0)
desVar("pvtn13" 0)
run()
selectResults('tran)
pup_val = average((clip((v("/vdd" ?result "tran") - v("/outn" ?result "tran")) 2e-07 2.5e-07) / clip(i("/xdrv_p/out" ?result "tran") 2e-07 2.5e-07)))
pdn_val = (average((clip(v("/outp" ?result "tran") 2e-07 2.5e-07) / clip(i("/xdrv_p/out" ?result "tran") 2e-07 2.5e-07))) * -1)
fprintf(out_file "BAD_17,FF,0.93,90.0,338336860,15,15,15,14,0,1,%f,%f,50.4,49.33\n" pup_val pdn_val)
drain(out_file)
printf("Result BAD_17 -> pup=%f, pdn=%f (GT Target: pup=50.4, pdn=49.33)\n" pup_val pdn_val)

; --- Sim 18/21: [BAD_18] FF, V=0.95V, T=-36.5C | ML=(12,13) GT=(12,12) ---
printf("\n>>> [job3_FF] Sim 18/21: BAD_18 (FF) V=0.95V, T=-36.5C | ML=(12,13) <<<\n")
desVar("tem" -36.5)
desVar("vreg" 0.95)
temp(-36.5)
desVar("pvt0" 0)
desVar("pvt1" 0)
desVar("pvt2" 1)
desVar("pvt3" 1)
desVar("pvt4" 0)
desVar("pvt5" 0)
desVar("pvt6" 0)
desVar("pvt7" 0)
desVar("pvt8" 0)
desVar("pvt9" 0)
desVar("pvt10" 0)
desVar("pvt11" 0)
desVar("pvt12" 0)
desVar("pvt13" 0)
desVar("pvtn0" 1)
desVar("pvtn1" 0)
desVar("pvtn2" 1)
desVar("pvtn3" 1)
desVar("pvtn4" 0)
desVar("pvtn5" 0)
desVar("pvtn6" 0)
desVar("pvtn7" 0)
desVar("pvtn8" 0)
desVar("pvtn9" 0)
desVar("pvtn10" 0)
desVar("pvtn11" 0)
desVar("pvtn12" 0)
desVar("pvtn13" 0)
run()
selectResults('tran)
pup_val = average((clip((v("/vdd" ?result "tran") - v("/outn" ?result "tran")) 2e-07 2.5e-07) / clip(i("/xdrv_p/out" ?result "tran") 2e-07 2.5e-07)))
pdn_val = (average((clip(v("/outp" ?result "tran") 2e-07 2.5e-07) / clip(i("/xdrv_p/out" ?result "tran") 2e-07 2.5e-07))) * -1)
fprintf(out_file "BAD_18,FF,0.95,-36.5,403420960,12,12,12,13,0,1,%f,%f,50.47,50.7\n" pup_val pdn_val)
drain(out_file)
printf("Result BAD_18 -> pup=%f, pdn=%f (GT Target: pup=50.47, pdn=50.7)\n" pup_val pdn_val)

; --- Sim 19/21: [BAD_19] FF, V=0.97V, T=-22.5C | ML=(12,13) GT=(13,13) ---
printf("\n>>> [job3_FF] Sim 19/21: BAD_19 (FF) V=0.97V, T=-22.5C | ML=(12,13) <<<\n")
desVar("tem" -22.5)
desVar("vreg" 0.97)
temp(-22.5)
desVar("pvt0" 0)
desVar("pvt1" 0)
desVar("pvt2" 1)
desVar("pvt3" 1)
desVar("pvt4" 0)
desVar("pvt5" 0)
desVar("pvt6" 0)
desVar("pvt7" 0)
desVar("pvt8" 0)
desVar("pvt9" 0)
desVar("pvt10" 0)
desVar("pvt11" 0)
desVar("pvt12" 0)
desVar("pvt13" 0)
desVar("pvtn0" 1)
desVar("pvtn1" 0)
desVar("pvtn2" 1)
desVar("pvtn3" 1)
desVar("pvtn4" 0)
desVar("pvtn5" 0)
desVar("pvtn6" 0)
desVar("pvtn7" 0)
desVar("pvtn8" 0)
desVar("pvtn9" 0)
desVar("pvtn10" 0)
desVar("pvtn11" 0)
desVar("pvtn12" 0)
desVar("pvtn13" 0)
run()
selectResults('tran)
pup_val = average((clip((v("/vdd" ?result "tran") - v("/outn" ?result "tran")) 2e-07 2.5e-07) / clip(i("/xdrv_p/out" ?result "tran") 2e-07 2.5e-07)))
pdn_val = (average((clip(v("/outp" ?result "tran") 2e-07 2.5e-07) / clip(i("/xdrv_p/out" ?result "tran") 2e-07 2.5e-07))) * -1)
fprintf(out_file "BAD_19,FF,0.97,-22.5,409057240,13,13,12,13,1,0,%f,%f,49.21,49.44\n" pup_val pdn_val)
drain(out_file)
printf("Result BAD_19 -> pup=%f, pdn=%f (GT Target: pup=49.21, pdn=49.44)\n" pup_val pdn_val)

; --- Sim 20/21: [BAD_20] FF, V=0.97V, T=30.0C | ML=(13,13) GT=(14,13) ---
printf("\n>>> [job3_FF] Sim 20/21: BAD_20 (FF) V=0.97V, T=30.0C | ML=(13,13) <<<\n")
desVar("tem" 30.0)
desVar("vreg" 0.97)
temp(30.0)
desVar("pvt0" 1)
desVar("pvt1" 0)
desVar("pvt2" 1)
desVar("pvt3" 1)
desVar("pvt4" 0)
desVar("pvt5" 0)
desVar("pvt6" 0)
desVar("pvt7" 0)
desVar("pvt8" 0)
desVar("pvt9" 0)
desVar("pvt10" 0)
desVar("pvt11" 0)
desVar("pvt12" 0)
desVar("pvt13" 0)
desVar("pvtn0" 1)
desVar("pvtn1" 0)
desVar("pvtn2" 1)
desVar("pvtn3" 1)
desVar("pvtn4" 0)
desVar("pvtn5" 0)
desVar("pvtn6" 0)
desVar("pvtn7" 0)
desVar("pvtn8" 0)
desVar("pvtn9" 0)
desVar("pvtn10" 0)
desVar("pvtn11" 0)
desVar("pvtn12" 0)
desVar("pvtn13" 0)
run()
selectResults('tran)
pup_val = average((clip((v("/vdd" ?result "tran") - v("/outn" ?result "tran")) 2e-07 2.5e-07) / clip(i("/xdrv_p/out" ?result "tran") 2e-07 2.5e-07)))
pdn_val = (average((clip(v("/outp" ?result "tran") 2e-07 2.5e-07) / clip(i("/xdrv_p/out" ?result "tran") 2e-07 2.5e-07))) * -1)
fprintf(out_file "BAD_20,FF,0.97,30.0,381106610,14,13,13,13,1,0,%f,%f,49.25,50.69\n" pup_val pdn_val)
drain(out_file)
printf("Result BAD_20 -> pup=%f, pdn=%f (GT Target: pup=49.25, pdn=50.69)\n" pup_val pdn_val)

; --- Sim 21/21: [BAD_21] FF, V=0.99V, T=104.5C | ML=(15,14) GT=(15,15) ---
printf("\n>>> [job3_FF] Sim 21/21: BAD_21 (FF) V=0.99V, T=104.5C | ML=(15,14) <<<\n")
desVar("tem" 104.5)
desVar("vreg" 0.99)
temp(104.5)
desVar("pvt0" 1)
desVar("pvt1" 1)
desVar("pvt2" 1)
desVar("pvt3" 1)
desVar("pvt4" 0)
desVar("pvt5" 0)
desVar("pvt6" 0)
desVar("pvt7" 0)
desVar("pvt8" 0)
desVar("pvt9" 0)
desVar("pvt10" 0)
desVar("pvt11" 0)
desVar("pvt12" 0)
desVar("pvt13" 0)
desVar("pvtn0" 0)
desVar("pvtn1" 1)
desVar("pvtn2" 1)
desVar("pvtn3" 1)
desVar("pvtn4" 0)
desVar("pvtn5" 0)
desVar("pvtn6" 0)
desVar("pvtn7" 0)
desVar("pvtn8" 0)
desVar("pvtn9" 0)
desVar("pvtn10" 0)
desVar("pvtn11" 0)
desVar("pvtn12" 0)
desVar("pvtn13" 0)
run()
selectResults('tran)
pup_val = average((clip((v("/vdd" ?result "tran") - v("/outn" ?result "tran")) 2e-07 2.5e-07) / clip(i("/xdrv_p/out" ?result "tran") 2e-07 2.5e-07)))
pdn_val = (average((clip(v("/outp" ?result "tran") 2e-07 2.5e-07) / clip(i("/xdrv_p/out" ?result "tran") 2e-07 2.5e-07))) * -1)
fprintf(out_file "BAD_21,FF,0.99,104.5,363980920,15,15,15,14,0,1,%f,%f,50.7,49.31\n" pup_val pdn_val)
drain(out_file)
printf("Result BAD_21 -> pup=%f, pdn=%f (GT Target: pup=50.7, pdn=49.31)\n" pup_val pdn_val)

close(out_file)
printf("\n=== JOB3_FF COMPLETED! Results in results_job3_FF.csv ===\n")
exit()
