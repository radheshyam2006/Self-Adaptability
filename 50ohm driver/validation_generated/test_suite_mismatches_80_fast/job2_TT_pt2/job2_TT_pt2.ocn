; =============================================================================
; CADENCE SPECTRE OCEAN SCRIPT: JOB2_TT_PT2 (TT CORNER)
; Total Test Cases: 19 | PDK Model: 1.8V (crn28hpcp_1d8_elk...)
; Simulating with ML PREDICTED TRIM to verify 48-52 Ohm Spec Compliance
; Results CSV: results_job2_TT_pt2.csv
; =============================================================================
simulator('spectre)
design("tsmc28_tx_tb" "tx_drv_ML" "schematic_seriliazer_top")
resultsDir("./ocean_results")

; modelFile declared once at top
modelFile(
    '("/data/cad/pdk_all/pdk_tsmc/pdk_tsmc_28/PDK/TSMC_new_iPDK/models/spectre/crn28hpcp_1d8_elk_v1d0_2p2_shrink0d9_embedded_usage.scs" "ttmacro_mos_moscap")
    '("/data/cad/pdk_all/pdk_tsmc/pdk_tsmc_28/PDK/TSMC_new_iPDK/models/spectre/crn28hpcp_1d8_elk_v1d0_2p2_shrink0d9_embedded_usage.scs" "tt_res_bip_dio_disres")
    '("/data/cad/pdk_all/pdk_tsmc/pdk_tsmc_28/PDK/TSMC_new_iPDK/models/spectre/crn28hpcp_1d8_elk_v1d0_2p2_shrink0d9_embedded_usage.scs" "pre_simu")
)

analysis('dc ?saveOppoint t)
analysis('tran ?stop "275n")
envOption('termDirectionMismatch "ignore" 'termMismatch "ignore")
saveOption( ?infoOptions list(list("modelParameter" "models" "rawfile" "" "" "" t) list("element" "inst" "rawfile" "" "" "" t) list("outputParameter" "output" "rawfile" "" "" "" t) list("designParamVals" "parameters" "rawfile" "" "" "" t) list("primitives" "primitives" "rawfile" "" "" "" t) list("subckts" "subckts" "rawfile" "" "" "" t) list("asserts" "assert" "rawfile" "" "" "" nil) list("extremeinfo" "all" "logfile" "" "yes" "" nil) list("allcap" "allcap" "file" "" "" "" nil) list("<Click_To_Add>" "none" "rawfile" "" "" "" nil) ) )
save('i "/xdrv_p/out")

out_file = outfile("results_job2_TT_pt2.csv")
fprintf(out_file "test_id,corner,vreg,temp,pmon,gt_pvtp,gt_pvtn,ml_pvtp,ml_pvtn,err_p,err_n,sim_pup,sim_pdn,gt_pup,gt_pdn\n")
drain(out_file)

; --- Sim 1/19: [BAD_62] TT, V=0.91V, T=7.0C | ML=(31,124) GT=(31,30) ---
printf("\n>>> [job2_TT_pt2] Sim 1/19: BAD_62 (TT) V=0.91V, T=7.0C | ML=(31,124) <<<\n")
desVar("tem" 7.0)
desVar("vreg" 0.91)
temp(7.0)
desVar("pvt0" 1)
desVar("pvt1" 1)
desVar("pvt2" 1)
desVar("pvt3" 1)
desVar("pvt4" 1)
desVar("pvt5" 0)
desVar("pvt6" 0)
desVar("pvt7" 0)
desVar("pvt8" 0)
desVar("pvt9" 0)
desVar("pvt10" 0)
desVar("pvt11" 0)
desVar("pvt12" 0)
desVar("pvt13" 0)
desVar("pvtn0" 0)
desVar("pvtn1" 0)
desVar("pvtn2" 1)
desVar("pvtn3" 1)
desVar("pvtn4" 1)
desVar("pvtn5" 1)
desVar("pvtn6" 1)
desVar("pvtn7" 0)
desVar("pvtn8" 0)
desVar("pvtn9" 0)
desVar("pvtn10" 0)
desVar("pvtn11" 0)
desVar("pvtn12" 0)
desVar("pvtn13" 0)
run()
selectResults('tran)
pup_val = average((clip((v("/vdd" ?result "tran") - v("/outn" ?result "tran")) 2e-07 2.5e-07) / clip(i("/xdrv_p/out" ?result "tran") 2e-07 2.5e-07)))
pdn_val = (average((clip(v("/outp" ?result "tran") 2e-07 2.5e-07) / clip(i("/xdrv_p/out" ?result "tran") 2e-07 2.5e-07))) * -1)
fprintf(out_file "BAD_62,TT,0.91,7.0,313029740,31,30,31,124,0,94,%f,%f,49.5,50.68\n" pup_val pdn_val)
drain(out_file)
printf("Result BAD_62 -> pup=%f, pdn=%f (GT Target: pup=49.5, pdn=50.68)\n" pup_val pdn_val)

; --- Sim 2/19: [BAD_63] TT, V=0.91V, T=7.5C | ML=(31,124) GT=(31,31) ---
printf("\n>>> [job2_TT_pt2] Sim 2/19: BAD_63 (TT) V=0.91V, T=7.5C | ML=(31,124) <<<\n")
desVar("tem" 7.5)
desVar("vreg" 0.91)
temp(7.5)
desVar("pvt0" 1)
desVar("pvt1" 1)
desVar("pvt2" 1)
desVar("pvt3" 1)
desVar("pvt4" 1)
desVar("pvt5" 0)
desVar("pvt6" 0)
desVar("pvt7" 0)
desVar("pvt8" 0)
desVar("pvt9" 0)
desVar("pvt10" 0)
desVar("pvt11" 0)
desVar("pvt12" 0)
desVar("pvt13" 0)
desVar("pvtn0" 0)
desVar("pvtn1" 0)
desVar("pvtn2" 1)
desVar("pvtn3" 1)
desVar("pvtn4" 1)
desVar("pvtn5" 1)
desVar("pvtn6" 1)
desVar("pvtn7" 0)
desVar("pvtn8" 0)
desVar("pvtn9" 0)
desVar("pvtn10" 0)
desVar("pvtn11" 0)
desVar("pvtn12" 0)
desVar("pvtn13" 0)
run()
selectResults('tran)
pup_val = average((clip((v("/vdd" ?result "tran") - v("/outn" ?result "tran")) 2e-07 2.5e-07) / clip(i("/xdrv_p/out" ?result "tran") 2e-07 2.5e-07)))
pdn_val = (average((clip(v("/outp" ?result "tran") 2e-07 2.5e-07) / clip(i("/xdrv_p/out" ?result "tran") 2e-07 2.5e-07))) * -1)
fprintf(out_file "BAD_63,TT,0.91,7.5,312860670,31,31,31,124,0,93,%f,%f,49.51,49.44\n" pup_val pdn_val)
drain(out_file)
printf("Result BAD_63 -> pup=%f, pdn=%f (GT Target: pup=49.51, pdn=49.44)\n" pup_val pdn_val)

; --- Sim 3/19: [BAD_64] TT, V=0.91V, T=8.0C | ML=(31,124) GT=(31,31) ---
printf("\n>>> [job2_TT_pt2] Sim 3/19: BAD_64 (TT) V=0.91V, T=8.0C | ML=(31,124) <<<\n")
desVar("tem" 8.0)
desVar("vreg" 0.91)
temp(8.0)
desVar("pvt0" 1)
desVar("pvt1" 1)
desVar("pvt2" 1)
desVar("pvt3" 1)
desVar("pvt4" 1)
desVar("pvt5" 0)
desVar("pvt6" 0)
desVar("pvt7" 0)
desVar("pvt8" 0)
desVar("pvt9" 0)
desVar("pvt10" 0)
desVar("pvt11" 0)
desVar("pvt12" 0)
desVar("pvt13" 0)
desVar("pvtn0" 0)
desVar("pvtn1" 0)
desVar("pvtn2" 1)
desVar("pvtn3" 1)
desVar("pvtn4" 1)
desVar("pvtn5" 1)
desVar("pvtn6" 1)
desVar("pvtn7" 0)
desVar("pvtn8" 0)
desVar("pvtn9" 0)
desVar("pvtn10" 0)
desVar("pvtn11" 0)
desVar("pvtn12" 0)
desVar("pvtn13" 0)
run()
selectResults('tran)
pup_val = average((clip((v("/vdd" ?result "tran") - v("/outn" ?result "tran")) 2e-07 2.5e-07) / clip(i("/xdrv_p/out" ?result "tran") 2e-07 2.5e-07)))
pdn_val = (average((clip(v("/outp" ?result "tran") 2e-07 2.5e-07) / clip(i("/xdrv_p/out" ?result "tran") 2e-07 2.5e-07))) * -1)
fprintf(out_file "BAD_64,TT,0.91,8.0,312722260,31,31,31,124,0,93,%f,%f,49.53,49.45\n" pup_val pdn_val)
drain(out_file)
printf("Result BAD_64 -> pup=%f, pdn=%f (GT Target: pup=49.53, pdn=49.45)\n" pup_val pdn_val)

; --- Sim 4/19: [BAD_65] TT, V=0.93V, T=-3.5C | ML=(122,30) GT=(30,30) ---
printf("\n>>> [job2_TT_pt2] Sim 4/19: BAD_65 (TT) V=0.93V, T=-3.5C | ML=(122,30) <<<\n")
desVar("tem" -3.5)
desVar("vreg" 0.93)
temp(-3.5)
desVar("pvt0" 0)
desVar("pvt1" 1)
desVar("pvt2" 0)
desVar("pvt3" 1)
desVar("pvt4" 1)
desVar("pvt5" 1)
desVar("pvt6" 1)
desVar("pvt7" 0)
desVar("pvt8" 0)
desVar("pvt9" 0)
desVar("pvt10" 0)
desVar("pvt11" 0)
desVar("pvt12" 0)
desVar("pvt13" 0)
desVar("pvtn0" 0)
desVar("pvtn1" 1)
desVar("pvtn2" 1)
desVar("pvtn3" 1)
desVar("pvtn4" 1)
desVar("pvtn5" 0)
desVar("pvtn6" 0)
desVar("pvtn7" 0)
desVar("pvtn8" 0)
desVar("pvtn9" 0)
desVar("pvtn10" 0)
desVar("pvtn11" 0)
desVar("pvtn12" 0)
desVar("pvtn13" 0)
run()
selectResults('tran)
pup_val = average((clip((v("/vdd" ?result "tran") - v("/outn" ?result "tran")) 2e-07 2.5e-07) / clip(i("/xdrv_p/out" ?result "tran") 2e-07 2.5e-07)))
pdn_val = (average((clip(v("/outp" ?result "tran") 2e-07 2.5e-07) / clip(i("/xdrv_p/out" ?result "tran") 2e-07 2.5e-07))) * -1)
fprintf(out_file "BAD_65,TT,0.93,-3.5,330036190,30,30,122,30,92,0,%f,%f,50.29,50.26\n" pup_val pdn_val)
drain(out_file)
printf("Result BAD_65 -> pup=%f, pdn=%f (GT Target: pup=50.29, pdn=50.26)\n" pup_val pdn_val)

; --- Sim 5/19: [BAD_66] TT, V=0.93V, T=15.5C | ML=(31,30) GT=(31,31) ---
printf("\n>>> [job2_TT_pt2] Sim 5/19: BAD_66 (TT) V=0.93V, T=15.5C | ML=(31,30) <<<\n")
desVar("tem" 15.5)
desVar("vreg" 0.93)
temp(15.5)
desVar("pvt0" 1)
desVar("pvt1" 1)
desVar("pvt2" 1)
desVar("pvt3" 1)
desVar("pvt4" 1)
desVar("pvt5" 0)
desVar("pvt6" 0)
desVar("pvt7" 0)
desVar("pvt8" 0)
desVar("pvt9" 0)
desVar("pvt10" 0)
desVar("pvt11" 0)
desVar("pvt12" 0)
desVar("pvt13" 0)
desVar("pvtn0" 0)
desVar("pvtn1" 1)
desVar("pvtn2" 1)
desVar("pvtn3" 1)
desVar("pvtn4" 1)
desVar("pvtn5" 0)
desVar("pvtn6" 0)
desVar("pvtn7" 0)
desVar("pvtn8" 0)
desVar("pvtn9" 0)
desVar("pvtn10" 0)
desVar("pvtn11" 0)
desVar("pvtn12" 0)
desVar("pvtn13" 0)
run()
selectResults('tran)
pup_val = average((clip((v("/vdd" ?result "tran") - v("/outn" ?result "tran")) 2e-07 2.5e-07) / clip(i("/xdrv_p/out" ?result "tran") 2e-07 2.5e-07)))
pdn_val = (average((clip(v("/outp" ?result "tran") 2e-07 2.5e-07) / clip(i("/xdrv_p/out" ?result "tran") 2e-07 2.5e-07))) * -1)
fprintf(out_file "BAD_66,TT,0.93,15.5,323451970,31,31,31,30,0,1,%f,%f,49.53,49.46\n" pup_val pdn_val)
drain(out_file)
printf("Result BAD_66 -> pup=%f, pdn=%f (GT Target: pup=49.53, pdn=49.46)\n" pup_val pdn_val)

; --- Sim 6/19: [BAD_67] TT, V=0.93V, T=118.0C | ML=(61,61) GT=(61,60) ---
printf("\n>>> [job2_TT_pt2] Sim 6/19: BAD_67 (TT) V=0.93V, T=118.0C | ML=(61,61) <<<\n")
desVar("tem" 118.0)
desVar("vreg" 0.93)
temp(118.0)
desVar("pvt0" 1)
desVar("pvt1" 0)
desVar("pvt2" 1)
desVar("pvt3" 1)
desVar("pvt4" 1)
desVar("pvt5" 1)
desVar("pvt6" 0)
desVar("pvt7" 0)
desVar("pvt8" 0)
desVar("pvt9" 0)
desVar("pvt10" 0)
desVar("pvt11" 0)
desVar("pvt12" 0)
desVar("pvt13" 0)
desVar("pvtn0" 1)
desVar("pvtn1" 0)
desVar("pvtn2" 1)
desVar("pvtn3" 1)
desVar("pvtn4" 1)
desVar("pvtn5" 1)
desVar("pvtn6" 0)
desVar("pvtn7" 0)
desVar("pvtn8" 0)
desVar("pvtn9" 0)
desVar("pvtn10" 0)
desVar("pvtn11" 0)
desVar("pvtn12" 0)
desVar("pvtn13" 0)
run()
selectResults('tran)
pup_val = average((clip((v("/vdd" ?result "tran") - v("/outn" ?result "tran")) 2e-07 2.5e-07) / clip(i("/xdrv_p/out" ?result "tran") 2e-07 2.5e-07)))
pdn_val = (average((clip(v("/outp" ?result "tran") 2e-07 2.5e-07) / clip(i("/xdrv_p/out" ?result "tran") 2e-07 2.5e-07))) * -1)
fprintf(out_file "BAD_67,TT,0.93,118.0,299521420,61,60,61,61,0,1,%f,%f,50.18,50.64\n" pup_val pdn_val)
drain(out_file)
printf("Result BAD_67 -> pup=%f, pdn=%f (GT Target: pup=50.18, pdn=50.64)\n" pup_val pdn_val)

; --- Sim 7/19: [BAD_68] TT, V=0.95V, T=-40.0C | ML=(29,29) GT=(61,61) ---
printf("\n>>> [job2_TT_pt2] Sim 7/19: BAD_68 (TT) V=0.95V, T=-40.0C | ML=(29,29) <<<\n")
desVar("tem" -40.0)
desVar("vreg" 0.95)
temp(-40.0)
desVar("pvt0" 1)
desVar("pvt1" 0)
desVar("pvt2" 1)
desVar("pvt3" 1)
desVar("pvt4" 1)
desVar("pvt5" 0)
desVar("pvt6" 0)
desVar("pvt7" 0)
desVar("pvt8" 0)
desVar("pvt9" 0)
desVar("pvt10" 0)
desVar("pvt11" 0)
desVar("pvt12" 0)
desVar("pvt13" 0)
desVar("pvtn0" 1)
desVar("pvtn1" 0)
desVar("pvtn2" 1)
desVar("pvtn3" 1)
desVar("pvtn4" 1)
desVar("pvtn5" 0)
desVar("pvtn6" 0)
desVar("pvtn7" 0)
desVar("pvtn8" 0)
desVar("pvtn9" 0)
desVar("pvtn10" 0)
desVar("pvtn11" 0)
desVar("pvtn12" 0)
desVar("pvtn13" 0)
run()
selectResults('tran)
pup_val = average((clip((v("/vdd" ?result "tran") - v("/outn" ?result "tran")) 2e-07 2.5e-07) / clip(i("/xdrv_p/out" ?result "tran") 2e-07 2.5e-07)))
pdn_val = (average((clip(v("/outp" ?result "tran") 2e-07 2.5e-07) / clip(i("/xdrv_p/out" ?result "tran") 2e-07 2.5e-07))) * -1)
fprintf(out_file "BAD_68,TT,0.95,-40.0,360920620,61,61,29,29,32,32,%f,%f,50.47,49.59\n" pup_val pdn_val)
drain(out_file)
printf("Result BAD_68 -> pup=%f, pdn=%f (GT Target: pup=50.47, pdn=49.59)\n" pup_val pdn_val)

; --- Sim 8/19: [BAD_69] TT, V=0.95V, T=-30.5C | ML=(30,30) GT=(29,30) ---
printf("\n>>> [job2_TT_pt2] Sim 8/19: BAD_69 (TT) V=0.95V, T=-30.5C | ML=(30,30) <<<\n")
desVar("tem" -30.5)
desVar("vreg" 0.95)
temp(-30.5)
desVar("pvt0" 0)
desVar("pvt1" 1)
desVar("pvt2" 1)
desVar("pvt3" 1)
desVar("pvt4" 1)
desVar("pvt5" 0)
desVar("pvt6" 0)
desVar("pvt7" 0)
desVar("pvt8" 0)
desVar("pvt9" 0)
desVar("pvt10" 0)
desVar("pvt11" 0)
desVar("pvt12" 0)
desVar("pvt13" 0)
desVar("pvtn0" 0)
desVar("pvtn1" 1)
desVar("pvtn2" 1)
desVar("pvtn3" 1)
desVar("pvtn4" 1)
desVar("pvtn5" 0)
desVar("pvtn6" 0)
desVar("pvtn7" 0)
desVar("pvtn8" 0)
desVar("pvtn9" 0)
desVar("pvtn10" 0)
desVar("pvtn11" 0)
desVar("pvtn12" 0)
desVar("pvtn13" 0)
run()
selectResults('tran)
pup_val = average((clip((v("/vdd" ?result "tran") - v("/outn" ?result "tran")) 2e-07 2.5e-07) / clip(i("/xdrv_p/out" ?result "tran") 2e-07 2.5e-07)))
pdn_val = (average((clip(v("/outp" ?result "tran") 2e-07 2.5e-07) / clip(i("/xdrv_p/out" ?result "tran") 2e-07 2.5e-07))) * -1)
fprintf(out_file "BAD_69,TT,0.95,-30.5,355867860,29,30,30,30,1,0,%f,%f,50.69,49.44\n" pup_val pdn_val)
drain(out_file)
printf("Result BAD_69 -> pup=%f, pdn=%f (GT Target: pup=50.69, pdn=49.44)\n" pup_val pdn_val)

; --- Sim 9/19: [BAD_70] TT, V=0.95V, T=-20.0C | ML=(122,30) GT=(30,30) ---
printf("\n>>> [job2_TT_pt2] Sim 9/19: BAD_70 (TT) V=0.95V, T=-20.0C | ML=(122,30) <<<\n")
desVar("tem" -20.0)
desVar("vreg" 0.95)
temp(-20.0)
desVar("pvt0" 0)
desVar("pvt1" 1)
desVar("pvt2" 0)
desVar("pvt3" 1)
desVar("pvt4" 1)
desVar("pvt5" 1)
desVar("pvt6" 1)
desVar("pvt7" 0)
desVar("pvt8" 0)
desVar("pvt9" 0)
desVar("pvt10" 0)
desVar("pvt11" 0)
desVar("pvt12" 0)
desVar("pvt13" 0)
desVar("pvtn0" 0)
desVar("pvtn1" 1)
desVar("pvtn2" 1)
desVar("pvtn3" 1)
desVar("pvtn4" 1)
desVar("pvtn5" 0)
desVar("pvtn6" 0)
desVar("pvtn7" 0)
desVar("pvtn8" 0)
desVar("pvtn9" 0)
desVar("pvtn10" 0)
desVar("pvtn11" 0)
desVar("pvtn12" 0)
desVar("pvtn13" 0)
run()
selectResults('tran)
pup_val = average((clip((v("/vdd" ?result "tran") - v("/outn" ?result "tran")) 2e-07 2.5e-07) / clip(i("/xdrv_p/out" ?result "tran") 2e-07 2.5e-07)))
pdn_val = (average((clip(v("/outp" ?result "tran") 2e-07 2.5e-07) / clip(i("/xdrv_p/out" ?result "tran") 2e-07 2.5e-07))) * -1)
fprintf(out_file "BAD_70,TT,0.95,-20.0,350769280,30,30,122,30,92,0,%f,%f,49.66,49.7\n" pup_val pdn_val)
drain(out_file)
printf("Result BAD_70 -> pup=%f, pdn=%f (GT Target: pup=49.66, pdn=49.7)\n" pup_val pdn_val)

; --- Sim 10/19: [BAD_71] TT, V=0.95V, T=-19.5C | ML=(122,30) GT=(30,30) ---
printf("\n>>> [job2_TT_pt2] Sim 10/19: BAD_71 (TT) V=0.95V, T=-19.5C | ML=(122,30) <<<\n")
desVar("tem" -19.5)
desVar("vreg" 0.95)
temp(-19.5)
desVar("pvt0" 0)
desVar("pvt1" 1)
desVar("pvt2" 0)
desVar("pvt3" 1)
desVar("pvt4" 1)
desVar("pvt5" 1)
desVar("pvt6" 1)
desVar("pvt7" 0)
desVar("pvt8" 0)
desVar("pvt9" 0)
desVar("pvt10" 0)
desVar("pvt11" 0)
desVar("pvt12" 0)
desVar("pvt13" 0)
desVar("pvtn0" 0)
desVar("pvtn1" 1)
desVar("pvtn2" 1)
desVar("pvtn3" 1)
desVar("pvtn4" 1)
desVar("pvtn5" 0)
desVar("pvtn6" 0)
desVar("pvtn7" 0)
desVar("pvtn8" 0)
desVar("pvtn9" 0)
desVar("pvtn10" 0)
desVar("pvtn11" 0)
desVar("pvtn12" 0)
desVar("pvtn13" 0)
run()
selectResults('tran)
pup_val = average((clip((v("/vdd" ?result "tran") - v("/outn" ?result "tran")) 2e-07 2.5e-07) / clip(i("/xdrv_p/out" ?result "tran") 2e-07 2.5e-07)))
pdn_val = (average((clip(v("/outp" ?result "tran") 2e-07 2.5e-07) / clip(i("/xdrv_p/out" ?result "tran") 2e-07 2.5e-07))) * -1)
fprintf(out_file "BAD_71,TT,0.95,-19.5,350518830,30,30,122,30,92,0,%f,%f,49.68,49.72\n" pup_val pdn_val)
drain(out_file)
printf("Result BAD_71 -> pup=%f, pdn=%f (GT Target: pup=49.68, pdn=49.72)\n" pup_val pdn_val)

; --- Sim 11/19: [BAD_72] TT, V=0.95V, T=19.5C | ML=(31,124) GT=(31,30) ---
printf("\n>>> [job2_TT_pt2] Sim 11/19: BAD_72 (TT) V=0.95V, T=19.5C | ML=(31,124) <<<\n")
desVar("tem" 19.5)
desVar("vreg" 0.95)
temp(19.5)
desVar("pvt0" 1)
desVar("pvt1" 1)
desVar("pvt2" 1)
desVar("pvt3" 1)
desVar("pvt4" 1)
desVar("pvt5" 0)
desVar("pvt6" 0)
desVar("pvt7" 0)
desVar("pvt8" 0)
desVar("pvt9" 0)
desVar("pvt10" 0)
desVar("pvt11" 0)
desVar("pvt12" 0)
desVar("pvt13" 0)
desVar("pvtn0" 0)
desVar("pvtn1" 0)
desVar("pvtn2" 1)
desVar("pvtn3" 1)
desVar("pvtn4" 1)
desVar("pvtn5" 1)
desVar("pvtn6" 1)
desVar("pvtn7" 0)
desVar("pvtn8" 0)
desVar("pvtn9" 0)
desVar("pvtn10" 0)
desVar("pvtn11" 0)
desVar("pvtn12" 0)
desVar("pvtn13" 0)
run()
selectResults('tran)
pup_val = average((clip((v("/vdd" ?result "tran") - v("/outn" ?result "tran")) 2e-07 2.5e-07) / clip(i("/xdrv_p/out" ?result "tran") 2e-07 2.5e-07)))
pdn_val = (average((clip(v("/outp" ?result "tran") 2e-07 2.5e-07) / clip(i("/xdrv_p/out" ?result "tran") 2e-07 2.5e-07))) * -1)
fprintf(out_file "BAD_72,TT,0.95,19.5,334688510,31,30,31,124,0,94,%f,%f,49.45,50.66\n" pup_val pdn_val)
drain(out_file)
printf("Result BAD_72 -> pup=%f, pdn=%f (GT Target: pup=49.45, pdn=50.66)\n" pup_val pdn_val)

; --- Sim 12/19: [BAD_73] TT, V=0.95V, T=20.0C | ML=(31,31) GT=(31,30) ---
printf("\n>>> [job2_TT_pt2] Sim 12/19: BAD_73 (TT) V=0.95V, T=20.0C | ML=(31,31) <<<\n")
desVar("tem" 20.0)
desVar("vreg" 0.95)
temp(20.0)
desVar("pvt0" 1)
desVar("pvt1" 1)
desVar("pvt2" 1)
desVar("pvt3" 1)
desVar("pvt4" 1)
desVar("pvt5" 0)
desVar("pvt6" 0)
desVar("pvt7" 0)
desVar("pvt8" 0)
desVar("pvt9" 0)
desVar("pvt10" 0)
desVar("pvt11" 0)
desVar("pvt12" 0)
desVar("pvt13" 0)
desVar("pvtn0" 1)
desVar("pvtn1" 1)
desVar("pvtn2" 1)
desVar("pvtn3" 1)
desVar("pvtn4" 1)
desVar("pvtn5" 0)
desVar("pvtn6" 0)
desVar("pvtn7" 0)
desVar("pvtn8" 0)
desVar("pvtn9" 0)
desVar("pvtn10" 0)
desVar("pvtn11" 0)
desVar("pvtn12" 0)
desVar("pvtn13" 0)
run()
selectResults('tran)
pup_val = average((clip((v("/vdd" ?result "tran") - v("/outn" ?result "tran")) 2e-07 2.5e-07) / clip(i("/xdrv_p/out" ?result "tran") 2e-07 2.5e-07)))
pdn_val = (average((clip(v("/outp" ?result "tran") 2e-07 2.5e-07) / clip(i("/xdrv_p/out" ?result "tran") 2e-07 2.5e-07))) * -1)
fprintf(out_file "BAD_73,TT,0.95,20.0,334494080,31,30,31,31,0,1,%f,%f,49.46,50.67\n" pup_val pdn_val)
drain(out_file)
printf("Result BAD_73 -> pup=%f, pdn=%f (GT Target: pup=49.46, pdn=50.67)\n" pup_val pdn_val)

; --- Sim 13/19: [BAD_74] TT, V=0.95V, T=65.0C | ML=(31,31) GT=(60,31) ---
printf("\n>>> [job2_TT_pt2] Sim 13/19: BAD_74 (TT) V=0.95V, T=65.0C | ML=(31,31) <<<\n")
desVar("tem" 65.0)
desVar("vreg" 0.95)
temp(65.0)
desVar("pvt0" 1)
desVar("pvt1" 1)
desVar("pvt2" 1)
desVar("pvt3" 1)
desVar("pvt4" 1)
desVar("pvt5" 0)
desVar("pvt6" 0)
desVar("pvt7" 0)
desVar("pvt8" 0)
desVar("pvt9" 0)
desVar("pvt10" 0)
desVar("pvt11" 0)
desVar("pvt12" 0)
desVar("pvt13" 0)
desVar("pvtn0" 1)
desVar("pvtn1" 1)
desVar("pvtn2" 1)
desVar("pvtn3" 1)
desVar("pvtn4" 1)
desVar("pvtn5" 0)
desVar("pvtn6" 0)
desVar("pvtn7" 0)
desVar("pvtn8" 0)
desVar("pvtn9" 0)
desVar("pvtn10" 0)
desVar("pvtn11" 0)
desVar("pvtn12" 0)
desVar("pvtn13" 0)
run()
selectResults('tran)
pup_val = average((clip((v("/vdd" ?result "tran") - v("/outn" ?result "tran")) 2e-07 2.5e-07) / clip(i("/xdrv_p/out" ?result "tran") 2e-07 2.5e-07)))
pdn_val = (average((clip(v("/outp" ?result "tran") 2e-07 2.5e-07) / clip(i("/xdrv_p/out" ?result "tran") 2e-07 2.5e-07))) * -1)
fprintf(out_file "BAD_74,TT,0.95,65.0,320876590,60,31,31,31,29,0,%f,%f,49.49,50.43\n" pup_val pdn_val)
drain(out_file)
printf("Result BAD_74 -> pup=%f, pdn=%f (GT Target: pup=49.49, pdn=50.43)\n" pup_val pdn_val)

; --- Sim 14/19: [BAD_75] TT, V=0.97V, T=-7.5C | ML=(30,123) GT=(30,30) ---
printf("\n>>> [job2_TT_pt2] Sim 14/19: BAD_75 (TT) V=0.97V, T=-7.5C | ML=(30,123) <<<\n")
desVar("tem" -7.5)
desVar("vreg" 0.97)
temp(-7.5)
desVar("pvt0" 0)
desVar("pvt1" 1)
desVar("pvt2" 1)
desVar("pvt3" 1)
desVar("pvt4" 1)
desVar("pvt5" 0)
desVar("pvt6" 0)
desVar("pvt7" 0)
desVar("pvt8" 0)
desVar("pvt9" 0)
desVar("pvt10" 0)
desVar("pvt11" 0)
desVar("pvt12" 0)
desVar("pvt13" 0)
desVar("pvtn0" 1)
desVar("pvtn1" 1)
desVar("pvtn2" 0)
desVar("pvtn3" 1)
desVar("pvtn4" 1)
desVar("pvtn5" 1)
desVar("pvtn6" 1)
desVar("pvtn7" 0)
desVar("pvtn8" 0)
desVar("pvtn9" 0)
desVar("pvtn10" 0)
desVar("pvtn11" 0)
desVar("pvtn12" 0)
desVar("pvtn13" 0)
run()
selectResults('tran)
pup_val = average((clip((v("/vdd" ?result "tran") - v("/outn" ?result "tran")) 2e-07 2.5e-07) / clip(i("/xdrv_p/out" ?result "tran") 2e-07 2.5e-07)))
pdn_val = (average((clip(v("/outp" ?result "tran") 2e-07 2.5e-07) / clip(i("/xdrv_p/out" ?result "tran") 2e-07 2.5e-07))) * -1)
fprintf(out_file "BAD_75,TT,0.97,-7.5,358449280,30,30,30,123,0,93,%f,%f,49.83,49.87\n" pup_val pdn_val)
drain(out_file)
printf("Result BAD_75 -> pup=%f, pdn=%f (GT Target: pup=49.83, pdn=49.87)\n" pup_val pdn_val)

; --- Sim 15/19: [BAD_76] TT, V=0.97V, T=-5.0C | ML=(30,123) GT=(30,30) ---
printf("\n>>> [job2_TT_pt2] Sim 15/19: BAD_76 (TT) V=0.97V, T=-5.0C | ML=(30,123) <<<\n")
desVar("tem" -5.0)
desVar("vreg" 0.97)
temp(-5.0)
desVar("pvt0" 0)
desVar("pvt1" 1)
desVar("pvt2" 1)
desVar("pvt3" 1)
desVar("pvt4" 1)
desVar("pvt5" 0)
desVar("pvt6" 0)
desVar("pvt7" 0)
desVar("pvt8" 0)
desVar("pvt9" 0)
desVar("pvt10" 0)
desVar("pvt11" 0)
desVar("pvt12" 0)
desVar("pvt13" 0)
desVar("pvtn0" 1)
desVar("pvtn1" 1)
desVar("pvtn2" 0)
desVar("pvtn3" 1)
desVar("pvtn4" 1)
desVar("pvtn5" 1)
desVar("pvtn6" 1)
desVar("pvtn7" 0)
desVar("pvtn8" 0)
desVar("pvtn9" 0)
desVar("pvtn10" 0)
desVar("pvtn11" 0)
desVar("pvtn12" 0)
desVar("pvtn13" 0)
run()
selectResults('tran)
pup_val = average((clip((v("/vdd" ?result "tran") - v("/outn" ?result "tran")) 2e-07 2.5e-07) / clip(i("/xdrv_p/out" ?result "tran") 2e-07 2.5e-07)))
pdn_val = (average((clip(v("/outp" ?result "tran") 2e-07 2.5e-07) / clip(i("/xdrv_p/out" ?result "tran") 2e-07 2.5e-07))) * -1)
fprintf(out_file "BAD_76,TT,0.97,-5.0,357288710,30,30,30,123,0,93,%f,%f,49.89,49.93\n" pup_val pdn_val)
drain(out_file)
printf("Result BAD_76 -> pup=%f, pdn=%f (GT Target: pup=49.89, pdn=49.93)\n" pup_val pdn_val)

; --- Sim 16/19: [BAD_77] TT, V=0.97V, T=83.5C | ML=(60,60) GT=(60,31) ---
printf("\n>>> [job2_TT_pt2] Sim 16/19: BAD_77 (TT) V=0.97V, T=83.5C | ML=(60,60) <<<\n")
desVar("tem" 83.5)
desVar("vreg" 0.97)
temp(83.5)
desVar("pvt0" 0)
desVar("pvt1" 0)
desVar("pvt2" 1)
desVar("pvt3" 1)
desVar("pvt4" 1)
desVar("pvt5" 1)
desVar("pvt6" 0)
desVar("pvt7" 0)
desVar("pvt8" 0)
desVar("pvt9" 0)
desVar("pvt10" 0)
desVar("pvt11" 0)
desVar("pvt12" 0)
desVar("pvt13" 0)
desVar("pvtn0" 0)
desVar("pvtn1" 0)
desVar("pvtn2" 1)
desVar("pvtn3" 1)
desVar("pvtn4" 1)
desVar("pvtn5" 1)
desVar("pvtn6" 0)
desVar("pvtn7" 0)
desVar("pvtn8" 0)
desVar("pvtn9" 0)
desVar("pvtn10" 0)
desVar("pvtn11" 0)
desVar("pvtn12" 0)
desVar("pvtn13" 0)
run()
selectResults('tran)
pup_val = average((clip((v("/vdd" ?result "tran") - v("/outn" ?result "tran")) 2e-07 2.5e-07) / clip(i("/xdrv_p/out" ?result "tran") 2e-07 2.5e-07)))
pdn_val = (average((clip(v("/outp" ?result "tran") 2e-07 2.5e-07) / clip(i("/xdrv_p/out" ?result "tran") 2e-07 2.5e-07))) * -1)
fprintf(out_file "BAD_77,TT,0.97,83.5,326529150,60,31,60,60,0,29,%f,%f,49.88,50.69\n" pup_val pdn_val)
drain(out_file)
printf("Result BAD_77 -> pup=%f, pdn=%f (GT Target: pup=49.88, pdn=50.69)\n" pup_val pdn_val)

; --- Sim 17/19: [BAD_78] TT, V=0.99V, T=29.0C | ML=(30,123) GT=(30,30) ---
printf("\n>>> [job2_TT_pt2] Sim 17/19: BAD_78 (TT) V=0.99V, T=29.0C | ML=(30,123) <<<\n")
desVar("tem" 29.0)
desVar("vreg" 0.99)
temp(29.0)
desVar("pvt0" 0)
desVar("pvt1" 1)
desVar("pvt2" 1)
desVar("pvt3" 1)
desVar("pvt4" 1)
desVar("pvt5" 0)
desVar("pvt6" 0)
desVar("pvt7" 0)
desVar("pvt8" 0)
desVar("pvt9" 0)
desVar("pvt10" 0)
desVar("pvt11" 0)
desVar("pvt12" 0)
desVar("pvt13" 0)
desVar("pvtn0" 1)
desVar("pvtn1" 1)
desVar("pvtn2" 0)
desVar("pvtn3" 1)
desVar("pvtn4" 1)
desVar("pvtn5" 1)
desVar("pvtn6" 1)
desVar("pvtn7" 0)
desVar("pvtn8" 0)
desVar("pvtn9" 0)
desVar("pvtn10" 0)
desVar("pvtn11" 0)
desVar("pvtn12" 0)
desVar("pvtn13" 0)
run()
selectResults('tran)
pup_val = average((clip((v("/vdd" ?result "tran") - v("/outn" ?result "tran")) 2e-07 2.5e-07) / clip(i("/xdrv_p/out" ?result "tran") 2e-07 2.5e-07)))
pdn_val = (average((clip(v("/outp" ?result "tran") 2e-07 2.5e-07) / clip(i("/xdrv_p/out" ?result "tran") 2e-07 2.5e-07))) * -1)
fprintf(out_file "BAD_78,TT,0.99,29.0,354988510,30,30,30,123,0,93,%f,%f,50.65,50.6\n" pup_val pdn_val)
drain(out_file)
printf("Result BAD_78 -> pup=%f, pdn=%f (GT Target: pup=50.65, pdn=50.6)\n" pup_val pdn_val)

; --- Sim 18/19: [BAD_79] TT, V=0.99V, T=30.5C | ML=(125,30) GT=(30,30) ---
printf("\n>>> [job2_TT_pt2] Sim 18/19: BAD_79 (TT) V=0.99V, T=30.5C | ML=(125,30) <<<\n")
desVar("tem" 30.5)
desVar("vreg" 0.99)
temp(30.5)
desVar("pvt0" 1)
desVar("pvt1" 0)
desVar("pvt2" 1)
desVar("pvt3" 1)
desVar("pvt4" 1)
desVar("pvt5" 1)
desVar("pvt6" 1)
desVar("pvt7" 0)
desVar("pvt8" 0)
desVar("pvt9" 0)
desVar("pvt10" 0)
desVar("pvt11" 0)
desVar("pvt12" 0)
desVar("pvt13" 0)
desVar("pvtn0" 0)
desVar("pvtn1" 1)
desVar("pvtn2" 1)
desVar("pvtn3" 1)
desVar("pvtn4" 1)
desVar("pvtn5" 0)
desVar("pvtn6" 0)
desVar("pvtn7" 0)
desVar("pvtn8" 0)
desVar("pvtn9" 0)
desVar("pvtn10" 0)
desVar("pvtn11" 0)
desVar("pvtn12" 0)
desVar("pvtn13" 0)
run()
selectResults('tran)
pup_val = average((clip((v("/vdd" ?result "tran") - v("/outn" ?result "tran")) 2e-07 2.5e-07) / clip(i("/xdrv_p/out" ?result "tran") 2e-07 2.5e-07)))
pdn_val = (average((clip(v("/outp" ?result "tran") 2e-07 2.5e-07) / clip(i("/xdrv_p/out" ?result "tran") 2e-07 2.5e-07))) * -1)
fprintf(out_file "BAD_79,TT,0.99,30.5,354395760,30,30,125,30,95,0,%f,%f,50.69,50.64\n" pup_val pdn_val)
drain(out_file)
printf("Result BAD_79 -> pup=%f, pdn=%f (GT Target: pup=50.69, pdn=50.64)\n" pup_val pdn_val)

; --- Sim 19/19: [BAD_80] TT, V=0.99V, T=100.0C | ML=(60,14) GT=(60,60) ---
printf("\n>>> [job2_TT_pt2] Sim 19/19: BAD_80 (TT) V=0.99V, T=100.0C | ML=(60,14) <<<\n")
desVar("tem" 100.0)
desVar("vreg" 0.99)
temp(100.0)
desVar("pvt0" 0)
desVar("pvt1" 0)
desVar("pvt2" 1)
desVar("pvt3" 1)
desVar("pvt4" 1)
desVar("pvt5" 1)
desVar("pvt6" 0)
desVar("pvt7" 0)
desVar("pvt8" 0)
desVar("pvt9" 0)
desVar("pvt10" 0)
desVar("pvt11" 0)
desVar("pvt12" 0)
desVar("pvt13" 0)
desVar("pvtn0" 0)
desVar("pvtn1" 1)
desVar("pvtn2" 1)
desVar("pvtn3" 1)
desVar("pvtn4" 0)
desVar("pvtn5" 0)
desVar("pvtn6" 0)
desVar("pvtn7" 0)
desVar("pvtn8" 0)
desVar("pvtn9" 0)
desVar("pvtn10" 0)
desVar("pvtn11" 0)
desVar("pvtn12" 0)
desVar("pvtn13" 0)
run()
selectResults('tran)
pup_val = average((clip((v("/vdd" ?result "tran") - v("/outn" ?result "tran")) 2e-07 2.5e-07) / clip(i("/xdrv_p/out" ?result "tran") 2e-07 2.5e-07)))
pdn_val = (average((clip(v("/outp" ?result "tran") 2e-07 2.5e-07) / clip(i("/xdrv_p/out" ?result "tran") 2e-07 2.5e-07))) * -1)
fprintf(out_file "BAD_80,TT,0.99,100.0,331965890,60,60,60,14,0,46,%f,%f,50.25,49.83\n" pup_val pdn_val)
drain(out_file)
printf("Result BAD_80 -> pup=%f, pdn=%f (GT Target: pup=50.25, pdn=49.83)\n" pup_val pdn_val)

close(out_file)
printf("\n=== JOB2_TT_PT2 COMPLETED! Results in results_job2_TT_pt2.csv ===\n")
exit()
