; =============================================================================
; CADENCE SPECTRE OCEAN SCRIPT: JOB 1 - TT
; Total Test Cases: 5 | PDK Model: 1.8V (crn28hpcp_1d8_elk...)
; Results CSV: results_job1_TT.csv | Results Directory: ./ocean_results_job1
; =============================================================================
simulator('spectre)
design("tsmc28_tx_tb" "tx_drv_ML" "schematic_seriliazer_top")
resultsDir("./ocean_results_job1")

; modelFile declared once at top
modelFile(
    '("/data/cad/pdk_all/pdk_tsmc/pdk_tsmc_28/PDK/TSMC_new_iPDK/models/spectre/crn28hpcp_1d8_elk_v1d0_2p2_shrink0d9_embedded_usage.scs" "ttmacro_mos_moscap")
    '("/data/cad/pdk_all/pdk_tsmc/pdk_tsmc_28/PDK/TSMC_new_iPDK/models/spectre/crn28hpcp_1d8_elk_v1d0_2p2_shrink0d9_embedded_usage.scs" "tt_res_bip_dio_disres")
    '("/data/cad/pdk_all/pdk_tsmc/pdk_tsmc_28/PDK/TSMC_new_iPDK/models/spectre/crn28hpcp_1d8_elk_v1d0_2p2_shrink0d9_embedded_usage.scs" "pre_simu")
)

analysis('dc ?saveOppoint t)
analysis('tran ?stop "275n")

envOption('termDirectionMismatch "ignore" 'termMismatch "ignore")
saveOption( ?infoOptions list(list("modelParameter" "models" "rawfile" "" "" "" t) list("element" "inst" "rawfile" "" "" "" t) list("outputParameter" "output" "rawfile" "" "" "" t) list("designParamVals" "parameters" "rawfile" "" "" "" t) list("primitives" "primitives" "rawfile" "" "" "" t) list("subckts" "subckts" "rawfile" "" "" "" t) list("asserts" "assert" "rawfile" "" "" "" nil) list("extremeinfo" "all" "logfile" "" "yes" "" nil) list("allcap" "allcap" "file" "" "" "" nil) list("<Click_To_Add>" "none" "rawfile" "" "" "" nil) ) )
save('i "/xdrv_p/out")

out_file = outfile("results_job1_TT.csv")
fprintf(out_file "test_id,corner,res_type,res_sec,vreg,temp,pmon,pvtp,pvtn,sim_pup,sim_pdn,excel_pup,excel_pdn\n")
drain(out_file)

; --- Sim 1/5: [GOOD_01] TT (Standard Resistor Corner), V=0.81V, T=-40.0C, pvtp=31, pvtn=31 ---
printf("\n>>> [JOB 1: TT] Running Sim 1/5: GOOD_01 (TT, tt_res_bip_dio_disres) V=0.81V, T=-40.0C <<<\n")
desVar("tem" -40.0)
desVar("vreg" 0.81)
temp(-40.0)
desVar("pvt0" 1)
desVar("pvt1" 1)
desVar("pvt2" 1)
desVar("pvt3" 1)
desVar("pvt4" 1)
desVar("pvt5" 0)
desVar("pvt6" 0)
desVar("pvt7" 0)
desVar("pvt8" 0)
desVar("pvt9" 0)
desVar("pvt10" 0)
desVar("pvt11" 0)
desVar("pvt12" 0)
desVar("pvt13" 0)
desVar("pvtn0" 1)
desVar("pvtn1" 1)
desVar("pvtn2" 1)
desVar("pvtn3" 1)
desVar("pvtn4" 1)
desVar("pvtn5" 0)
desVar("pvtn6" 0)
desVar("pvtn7" 0)
desVar("pvtn8" 0)
desVar("pvtn9" 0)
desVar("pvtn10" 0)
desVar("pvtn11" 0)
desVar("pvtn12" 0)
desVar("pvtn13" 0)
run()
selectResults('tran)
pup_val = average((clip((v("/vdd" ?result "tran") - v("/outn" ?result "tran")) 2e-07 2.5e-07) / clip(i("/xdrv_p/out" ?result "tran") 2e-07 2.5e-07)))
pdn_val = (average((clip(v("/outp" ?result "tran") 2e-07 2.5e-07) / clip(i("/xdrv_p/out" ?result "tran") 2e-07 2.5e-07))) * -1)
fprintf(out_file "GOOD_01,TT,Standard Resistor Corner,tt_res_bip_dio_disres,0.81,-40.0,248568380,31,31,%f,%f,49.33,49.62\n" pup_val pdn_val)
drain(out_file)
printf("Result GOOD_01 -> pup=%f, pdn=%f (Target: pup=49.33, pdn=49.62)\n" pup_val pdn_val)

; --- Sim 2/5: [GOOD_02] TT (Standard Resistor Corner), V=0.99V, T=-7.5C, pvtp=30, pvtn=30 ---
printf("\n>>> [JOB 1: TT] Running Sim 2/5: GOOD_02 (TT, tt_res_bip_dio_disres) V=0.99V, T=-7.5C <<<\n")
desVar("tem" -7.5)
desVar("vreg" 0.99)
temp(-7.5)
desVar("pvt0" 0)
desVar("pvt1" 1)
desVar("pvt2" 1)
desVar("pvt3" 1)
desVar("pvt4" 1)
desVar("pvt5" 0)
desVar("pvt6" 0)
desVar("pvt7" 0)
desVar("pvt8" 0)
desVar("pvt9" 0)
desVar("pvt10" 0)
desVar("pvt11" 0)
desVar("pvt12" 0)
desVar("pvt13" 0)
desVar("pvtn0" 0)
desVar("pvtn1" 1)
desVar("pvtn2" 1)
desVar("pvtn3" 1)
desVar("pvtn4" 1)
desVar("pvtn5" 0)
desVar("pvtn6" 0)
desVar("pvtn7" 0)
desVar("pvtn8" 0)
desVar("pvtn9" 0)
desVar("pvtn10" 0)
desVar("pvtn11" 0)
desVar("pvtn12" 0)
desVar("pvtn13" 0)
run()
selectResults('tran)
pup_val = average((clip((v("/vdd" ?result "tran") - v("/outn" ?result "tran")) 2e-07 2.5e-07) / clip(i("/xdrv_p/out" ?result "tran") 2e-07 2.5e-07)))
pdn_val = (average((clip(v("/outp" ?result "tran") 2e-07 2.5e-07) / clip(i("/xdrv_p/out" ?result "tran") 2e-07 2.5e-07))) * -1)
fprintf(out_file "GOOD_02,TT,Standard Resistor Corner,tt_res_bip_dio_disres,0.99,-7.5,371445940,30,30,%f,%f,49.68,49.73\n" pup_val pdn_val)
drain(out_file)
printf("Result GOOD_02 -> pup=%f, pdn=%f (Target: pup=49.68, pdn=49.73)\n" pup_val pdn_val)

; --- Sim 3/5: [GOOD_03] TT (Standard Resistor Corner), V=0.87V, T=26.0C, pvtp=31, pvtn=31 ---
printf("\n>>> [JOB 1: TT] Running Sim 3/5: GOOD_03 (TT, tt_res_bip_dio_disres) V=0.87V, T=26.0C <<<\n")
desVar("tem" 26.0)
desVar("vreg" 0.87)
temp(26.0)
desVar("pvt0" 1)
desVar("pvt1" 1)
desVar("pvt2" 1)
desVar("pvt3" 1)
desVar("pvt4" 1)
desVar("pvt5" 0)
desVar("pvt6" 0)
desVar("pvt7" 0)
desVar("pvt8" 0)
desVar("pvt9" 0)
desVar("pvt10" 0)
desVar("pvt11" 0)
desVar("pvt12" 0)
desVar("pvt13" 0)
desVar("pvtn0" 1)
desVar("pvtn1" 1)
desVar("pvtn2" 1)
desVar("pvtn3" 1)
desVar("pvtn4" 1)
desVar("pvtn5" 0)
desVar("pvtn6" 0)
desVar("pvtn7" 0)
desVar("pvtn8" 0)
desVar("pvtn9" 0)
desVar("pvtn10" 0)
desVar("pvtn11" 0)
desVar("pvtn12" 0)
desVar("pvtn13" 0)
run()
selectResults('tran)
pup_val = average((clip((v("/vdd" ?result "tran") - v("/outn" ?result "tran")) 2e-07 2.5e-07) / clip(i("/xdrv_p/out" ?result "tran") 2e-07 2.5e-07)))
pdn_val = (average((clip(v("/outp" ?result "tran") 2e-07 2.5e-07) / clip(i("/xdrv_p/out" ?result "tran") 2e-07 2.5e-07))) * -1)
fprintf(out_file "GOOD_03,TT,Standard Resistor Corner,tt_res_bip_dio_disres,0.87,26.0,281834670,31,31,%f,%f,50.51,50.26\n" pup_val pdn_val)
drain(out_file)
printf("Result GOOD_03 -> pup=%f, pdn=%f (Target: pup=50.51, pdn=50.26)\n" pup_val pdn_val)

; --- Sim 4/5: [GOOD_04] TT (Standard Resistor Corner), V=0.87V, T=59.5C, pvtp=60, pvtn=60 ---
printf("\n>>> [JOB 1: TT] Running Sim 4/5: GOOD_04 (TT, tt_res_bip_dio_disres) V=0.87V, T=59.5C <<<\n")
desVar("tem" 59.5)
desVar("vreg" 0.87)
temp(59.5)
desVar("pvt0" 0)
desVar("pvt1" 0)
desVar("pvt2" 1)
desVar("pvt3" 1)
desVar("pvt4" 1)
desVar("pvt5" 1)
desVar("pvt6" 0)
desVar("pvt7" 0)
desVar("pvt8" 0)
desVar("pvt9" 0)
desVar("pvt10" 0)
desVar("pvt11" 0)
desVar("pvt12" 0)
desVar("pvt13" 0)
desVar("pvtn0" 0)
desVar("pvtn1" 0)
desVar("pvtn2" 1)
desVar("pvtn3" 1)
desVar("pvtn4" 1)
desVar("pvtn5" 1)
desVar("pvtn6" 0)
desVar("pvtn7" 0)
desVar("pvtn8" 0)
desVar("pvtn9" 0)
desVar("pvtn10" 0)
desVar("pvtn11" 0)
desVar("pvtn12" 0)
desVar("pvtn13" 0)
run()
selectResults('tran)
pup_val = average((clip((v("/vdd" ?result "tran") - v("/outn" ?result "tran")) 2e-07 2.5e-07) / clip(i("/xdrv_p/out" ?result "tran") 2e-07 2.5e-07)))
pdn_val = (average((clip(v("/outp" ?result "tran") 2e-07 2.5e-07) / clip(i("/xdrv_p/out" ?result "tran") 2e-07 2.5e-07))) * -1)
fprintf(out_file "GOOD_04,TT,Standard Resistor Corner,tt_res_bip_dio_disres,0.87,59.5,276418580,60,60,%f,%f,50.21,49.92\n" pup_val pdn_val)
drain(out_file)
printf("Result GOOD_04 -> pup=%f, pdn=%f (Target: pup=50.21, pdn=49.92)\n" pup_val pdn_val)

; --- Sim 5/5: [GOOD_05] TT (Standard Resistor Corner), V=0.99V, T=125.0C, pvtp=61, pvtn=60 ---
printf("\n>>> [JOB 1: TT] Running Sim 5/5: GOOD_05 (TT, tt_res_bip_dio_disres) V=0.99V, T=125.0C <<<\n")
desVar("tem" 125.0)
desVar("vreg" 0.99)
temp(125.0)
desVar("pvt0" 1)
desVar("pvt1" 0)
desVar("pvt2" 1)
desVar("pvt3" 1)
desVar("pvt4" 1)
desVar("pvt5" 1)
desVar("pvt6" 0)
desVar("pvt7" 0)
desVar("pvt8" 0)
desVar("pvt9" 0)
desVar("pvt10" 0)
desVar("pvt11" 0)
desVar("pvt12" 0)
desVar("pvt13" 0)
desVar("pvtn0" 0)
desVar("pvtn1" 0)
desVar("pvtn2" 1)
desVar("pvtn3" 1)
desVar("pvtn4" 1)
desVar("pvtn5" 1)
desVar("pvtn6" 0)
desVar("pvtn7" 0)
desVar("pvtn8" 0)
desVar("pvtn9" 0)
desVar("pvtn10" 0)
desVar("pvtn11" 0)
desVar("pvtn12" 0)
desVar("pvtn13" 0)
run()
selectResults('tran)
pup_val = average((clip((v("/vdd" ?result "tran") - v("/outn" ?result "tran")) 2e-07 2.5e-07) / clip(i("/xdrv_p/out" ?result "tran") 2e-07 2.5e-07)))
pdn_val = (average((clip(v("/outp" ?result "tran") 2e-07 2.5e-07) / clip(i("/xdrv_p/out" ?result "tran") 2e-07 2.5e-07))) * -1)
fprintf(out_file "GOOD_05,TT,Standard Resistor Corner,tt_res_bip_dio_disres,0.99,125.0,325808470,61,60,%f,%f,49.92,50.36\n" pup_val pdn_val)
drain(out_file)
printf("Result GOOD_05 -> pup=%f, pdn=%f (Target: pup=49.92, pdn=50.36)\n" pup_val pdn_val)

close(out_file)
printf("\n=== JOB 1 (TT) COMPLETED! Results saved to results_job1_TT.csv ===\n")
exit()
