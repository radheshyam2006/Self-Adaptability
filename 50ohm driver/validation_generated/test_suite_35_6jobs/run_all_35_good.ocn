; =============================================================================
; ALL 35 GOOD TEST CASES - SINGLE CONTINUOUS OCEAN SCRIPT
; PDK Model: 1.8V (crn28hpcp_1d8_elk...) | Dual Resistor Cross Corners
; Output CSV: results_all_35_good.csv
; Total Runtime: ~60 seconds
; =============================================================================
simulator('spectre)
design("tsmc28_tx_tb" "tx_drv_ML" "schematic_seriliazer_top")
resultsDir("./ocean_results_all35")
analysis('dc ?saveOppoint t)
analysis('tran ?stop "275n")
envOption('termDirectionMismatch "ignore" 'termMismatch "ignore")
saveOption( ?infoOptions list(list("modelParameter" "models" "rawfile" "" "" "" t) list("element" "inst" "rawfile" "" "" "" t) list("outputParameter" "output" "rawfile" "" "" "" t) list("designParamVals" "parameters" "rawfile" "" "" "" t) list("primitives" "primitives" "rawfile" "" "" "" t) list("subckts" "subckts" "rawfile" "" "" "" t) list("asserts" "assert" "rawfile" "" "" "" nil) list("extremeinfo" "all" "logfile" "" "yes" "" nil) list("allcap" "allcap" "file" "" "" "" nil) list("<Click_To_Add>" "none" "rawfile" "" "" "" nil) ) )
save('i "/xdrv_p/out")

out_file = outfile("results_all_35_good.csv")
fprintf(out_file "test_id,corner,res_type,res_sec,vreg,temp,pmon,pvtp,pvtn,sim_pup,sim_pdn,excel_pup,excel_pdn\n")
drain(out_file)

; --- Sim 1/35: [GOOD_01] TT (Standard Resistor Corner), V=0.81V, T=-40.0C, pvtp=31, pvtn=31 ---
modelFile(
    '("/data/cad/pdk_all/pdk_tsmc/pdk_tsmc_28/PDK/TSMC_new_iPDK/models/spectre/crn28hpcp_1d8_elk_v1d0_2p2_shrink0d9_embedded_usage.scs" "ttmacro_mos_moscap")
    '("/data/cad/pdk_all/pdk_tsmc/pdk_tsmc_28/PDK/TSMC_new_iPDK/models/spectre/crn28hpcp_1d8_elk_v1d0_2p2_shrink0d9_embedded_usage.scs" "tt_res_bip_dio_disres")
    '("/data/cad/pdk_all/pdk_tsmc/pdk_tsmc_28/PDK/TSMC_new_iPDK/models/spectre/crn28hpcp_1d8_elk_v1d0_2p2_shrink0d9_embedded_usage.scs" "pre_simu")
)
printf("\n>>> Running Sim 1/35: GOOD_01 (TT, tt_res_bip_dio_disres) V=0.81V, T=-40.0C <<<\n")
desVar("tem" -40.0)
desVar("vreg" 0.81)
temp(-40.0)
desVar("pvt0" 1)
desVar("pvt1" 1)
desVar("pvt2" 1)
desVar("pvt3" 1)
desVar("pvt4" 1)
desVar("pvt5" 0)
desVar("pvt6" 0)
desVar("pvt7" 0)
desVar("pvt8" 0)
desVar("pvt9" 0)
desVar("pvt10" 0)
desVar("pvt11" 0)
desVar("pvt12" 0)
desVar("pvt13" 0)
desVar("pvtn0" 1)
desVar("pvtn1" 1)
desVar("pvtn2" 1)
desVar("pvtn3" 1)
desVar("pvtn4" 1)
desVar("pvtn5" 0)
desVar("pvtn6" 0)
desVar("pvtn7" 0)
desVar("pvtn8" 0)
desVar("pvtn9" 0)
desVar("pvtn10" 0)
desVar("pvtn11" 0)
desVar("pvtn12" 0)
desVar("pvtn13" 0)
run()
selectResults('tran)
pup_val = average((clip((v("/vdd" ?result "tran") - v("/outn" ?result "tran")) 2e-07 2.5e-07) / clip(i("/xdrv_p/out" ?result "tran") 2e-07 2.5e-07)))
pdn_val = (average((clip(v("/outp" ?result "tran") 2e-07 2.5e-07) / clip(i("/xdrv_p/out" ?result "tran") 2e-07 2.5e-07))) * -1)
fprintf(out_file "GOOD_01,TT,Standard Resistor Corner,tt_res_bip_dio_disres,0.81,-40.0,248568380,31,31,%f,%f,49.33,49.62\n" pup_val pdn_val)
drain(out_file)
printf("Result GOOD_01 -> pup=%f, pdn=%f (Target: pup=49.33, pdn=49.62)\n" pup_val pdn_val)

; --- Sim 2/35: [GOOD_02] TT (Standard Resistor Corner), V=0.99V, T=-7.5C, pvtp=30, pvtn=30 ---
printf("\n>>> Running Sim 2/35: GOOD_02 (TT, tt_res_bip_dio_disres) V=0.99V, T=-7.5C <<<\n")
desVar("tem" -7.5)
desVar("vreg" 0.99)
temp(-7.5)
desVar("pvt0" 0)
desVar("pvt1" 1)
desVar("pvt2" 1)
desVar("pvt3" 1)
desVar("pvt4" 1)
desVar("pvt5" 0)
desVar("pvt6" 0)
desVar("pvt7" 0)
desVar("pvt8" 0)
desVar("pvt9" 0)
desVar("pvt10" 0)
desVar("pvt11" 0)
desVar("pvt12" 0)
desVar("pvt13" 0)
desVar("pvtn0" 0)
desVar("pvtn1" 1)
desVar("pvtn2" 1)
desVar("pvtn3" 1)
desVar("pvtn4" 1)
desVar("pvtn5" 0)
desVar("pvtn6" 0)
desVar("pvtn7" 0)
desVar("pvtn8" 0)
desVar("pvtn9" 0)
desVar("pvtn10" 0)
desVar("pvtn11" 0)
desVar("pvtn12" 0)
desVar("pvtn13" 0)
run()
selectResults('tran)
pup_val = average((clip((v("/vdd" ?result "tran") - v("/outn" ?result "tran")) 2e-07 2.5e-07) / clip(i("/xdrv_p/out" ?result "tran") 2e-07 2.5e-07)))
pdn_val = (average((clip(v("/outp" ?result "tran") 2e-07 2.5e-07) / clip(i("/xdrv_p/out" ?result "tran") 2e-07 2.5e-07))) * -1)
fprintf(out_file "GOOD_02,TT,Standard Resistor Corner,tt_res_bip_dio_disres,0.99,-7.5,371445940,30,30,%f,%f,49.68,49.73\n" pup_val pdn_val)
drain(out_file)
printf("Result GOOD_02 -> pup=%f, pdn=%f (Target: pup=49.68, pdn=49.73)\n" pup_val pdn_val)

; --- Sim 3/35: [GOOD_03] TT (Standard Resistor Corner), V=0.87V, T=26.0C, pvtp=31, pvtn=31 ---
printf("\n>>> Running Sim 3/35: GOOD_03 (TT, tt_res_bip_dio_disres) V=0.87V, T=26.0C <<<\n")
desVar("tem" 26.0)
desVar("vreg" 0.87)
temp(26.0)
desVar("pvt0" 1)
desVar("pvt1" 1)
desVar("pvt2" 1)
desVar("pvt3" 1)
desVar("pvt4" 1)
desVar("pvt5" 0)
desVar("pvt6" 0)
desVar("pvt7" 0)
desVar("pvt8" 0)
desVar("pvt9" 0)
desVar("pvt10" 0)
desVar("pvt11" 0)
desVar("pvt12" 0)
desVar("pvt13" 0)
desVar("pvtn0" 1)
desVar("pvtn1" 1)
desVar("pvtn2" 1)
desVar("pvtn3" 1)
desVar("pvtn4" 1)
desVar("pvtn5" 0)
desVar("pvtn6" 0)
desVar("pvtn7" 0)
desVar("pvtn8" 0)
desVar("pvtn9" 0)
desVar("pvtn10" 0)
desVar("pvtn11" 0)
desVar("pvtn12" 0)
desVar("pvtn13" 0)
run()
selectResults('tran)
pup_val = average((clip((v("/vdd" ?result "tran") - v("/outn" ?result "tran")) 2e-07 2.5e-07) / clip(i("/xdrv_p/out" ?result "tran") 2e-07 2.5e-07)))
pdn_val = (average((clip(v("/outp" ?result "tran") 2e-07 2.5e-07) / clip(i("/xdrv_p/out" ?result "tran") 2e-07 2.5e-07))) * -1)
fprintf(out_file "GOOD_03,TT,Standard Resistor Corner,tt_res_bip_dio_disres,0.87,26.0,281834670,31,31,%f,%f,50.51,50.26\n" pup_val pdn_val)
drain(out_file)
printf("Result GOOD_03 -> pup=%f, pdn=%f (Target: pup=50.51, pdn=50.26)\n" pup_val pdn_val)

; --- Sim 4/35: [GOOD_04] TT (Standard Resistor Corner), V=0.87V, T=59.5C, pvtp=60, pvtn=60 ---
printf("\n>>> Running Sim 4/35: GOOD_04 (TT, tt_res_bip_dio_disres) V=0.87V, T=59.5C <<<\n")
desVar("tem" 59.5)
desVar("vreg" 0.87)
temp(59.5)
desVar("pvt0" 0)
desVar("pvt1" 0)
desVar("pvt2" 1)
desVar("pvt3" 1)
desVar("pvt4" 1)
desVar("pvt5" 1)
desVar("pvt6" 0)
desVar("pvt7" 0)
desVar("pvt8" 0)
desVar("pvt9" 0)
desVar("pvt10" 0)
desVar("pvt11" 0)
desVar("pvt12" 0)
desVar("pvt13" 0)
desVar("pvtn0" 0)
desVar("pvtn1" 0)
desVar("pvtn2" 1)
desVar("pvtn3" 1)
desVar("pvtn4" 1)
desVar("pvtn5" 1)
desVar("pvtn6" 0)
desVar("pvtn7" 0)
desVar("pvtn8" 0)
desVar("pvtn9" 0)
desVar("pvtn10" 0)
desVar("pvtn11" 0)
desVar("pvtn12" 0)
desVar("pvtn13" 0)
run()
selectResults('tran)
pup_val = average((clip((v("/vdd" ?result "tran") - v("/outn" ?result "tran")) 2e-07 2.5e-07) / clip(i("/xdrv_p/out" ?result "tran") 2e-07 2.5e-07)))
pdn_val = (average((clip(v("/outp" ?result "tran") 2e-07 2.5e-07) / clip(i("/xdrv_p/out" ?result "tran") 2e-07 2.5e-07))) * -1)
fprintf(out_file "GOOD_04,TT,Standard Resistor Corner,tt_res_bip_dio_disres,0.87,59.5,276418580,60,60,%f,%f,50.21,49.92\n" pup_val pdn_val)
drain(out_file)
printf("Result GOOD_04 -> pup=%f, pdn=%f (Target: pup=50.21, pdn=49.92)\n" pup_val pdn_val)

; --- Sim 5/35: [GOOD_05] TT (Standard Resistor Corner), V=0.99V, T=125.0C, pvtp=61, pvtn=60 ---
printf("\n>>> Running Sim 5/35: GOOD_05 (TT, tt_res_bip_dio_disres) V=0.99V, T=125.0C <<<\n")
desVar("tem" 125.0)
desVar("vreg" 0.99)
temp(125.0)
desVar("pvt0" 1)
desVar("pvt1" 0)
desVar("pvt2" 1)
desVar("pvt3" 1)
desVar("pvt4" 1)
desVar("pvt5" 1)
desVar("pvt6" 0)
desVar("pvt7" 0)
desVar("pvt8" 0)
desVar("pvt9" 0)
desVar("pvt10" 0)
desVar("pvt11" 0)
desVar("pvt12" 0)
desVar("pvt13" 0)
desVar("pvtn0" 0)
desVar("pvtn1" 0)
desVar("pvtn2" 1)
desVar("pvtn3" 1)
desVar("pvtn4" 1)
desVar("pvtn5" 1)
desVar("pvtn6" 0)
desVar("pvtn7" 0)
desVar("pvtn8" 0)
desVar("pvtn9" 0)
desVar("pvtn10" 0)
desVar("pvtn11" 0)
desVar("pvtn12" 0)
desVar("pvtn13" 0)
run()
selectResults('tran)
pup_val = average((clip((v("/vdd" ?result "tran") - v("/outn" ?result "tran")) 2e-07 2.5e-07) / clip(i("/xdrv_p/out" ?result "tran") 2e-07 2.5e-07)))
pdn_val = (average((clip(v("/outp" ?result "tran") 2e-07 2.5e-07) / clip(i("/xdrv_p/out" ?result "tran") 2e-07 2.5e-07))) * -1)
fprintf(out_file "GOOD_05,TT,Standard Resistor Corner,tt_res_bip_dio_disres,0.99,125.0,325808470,61,60,%f,%f,49.92,50.36\n" pup_val pdn_val)
drain(out_file)
printf("Result GOOD_05 -> pup=%f, pdn=%f (Target: pup=49.92, pdn=50.36)\n" pup_val pdn_val)

; --- Sim 6/35: [GOOD_06] FF (Standard Resistor Corner), V=0.81V, T=-40.0C, pvtp=13, pvtn=13 ---
modelFile(
    '("/data/cad/pdk_all/pdk_tsmc/pdk_tsmc_28/PDK/TSMC_new_iPDK/models/spectre/crn28hpcp_1d8_elk_v1d0_2p2_shrink0d9_embedded_usage.scs" "ffmacro_mos_moscap")
    '("/data/cad/pdk_all/pdk_tsmc/pdk_tsmc_28/PDK/TSMC_new_iPDK/models/spectre/crn28hpcp_1d8_elk_v1d0_2p2_shrink0d9_embedded_usage.scs" "ff_res_bip_dio_disres")
    '("/data/cad/pdk_all/pdk_tsmc/pdk_tsmc_28/PDK/TSMC_new_iPDK/models/spectre/crn28hpcp_1d8_elk_v1d0_2p2_shrink0d9_embedded_usage.scs" "pre_simu")
)
printf("\n>>> Running Sim 6/35: GOOD_06 (FF, ff_res_bip_dio_disres) V=0.81V, T=-40.0C <<<\n")
desVar("tem" -40.0)
desVar("vreg" 0.81)
temp(-40.0)
desVar("pvt0" 1)
desVar("pvt1" 0)
desVar("pvt2" 1)
desVar("pvt3" 1)
desVar("pvt4" 0)
desVar("pvt5" 0)
desVar("pvt6" 0)
desVar("pvt7" 0)
desVar("pvt8" 0)
desVar("pvt9" 0)
desVar("pvt10" 0)
desVar("pvt11" 0)
desVar("pvt12" 0)
desVar("pvt13" 0)
desVar("pvtn0" 1)
desVar("pvtn1" 0)
desVar("pvtn2" 1)
desVar("pvtn3" 1)
desVar("pvtn4" 0)
desVar("pvtn5" 0)
desVar("pvtn6" 0)
desVar("pvtn7" 0)
desVar("pvtn8" 0)
desVar("pvtn9" 0)
desVar("pvtn10" 0)
desVar("pvtn11" 0)
desVar("pvtn12" 0)
desVar("pvtn13" 0)
run()
selectResults('tran)
pup_val = average((clip((v("/vdd" ?result "tran") - v("/outn" ?result "tran")) 2e-07 2.5e-07) / clip(i("/xdrv_p/out" ?result "tran") 2e-07 2.5e-07)))
pdn_val = (average((clip(v("/outp" ?result "tran") 2e-07 2.5e-07) / clip(i("/xdrv_p/out" ?result "tran") 2e-07 2.5e-07))) * -1)
fprintf(out_file "GOOD_06,FF,Standard Resistor Corner,ff_res_bip_dio_disres,0.81,-40.0,290279170,13,13,%f,%f,50.22,50.3\n" pup_val pdn_val)
drain(out_file)
printf("Result GOOD_06 -> pup=%f, pdn=%f (Target: pup=50.22, pdn=50.3)\n" pup_val pdn_val)

; --- Sim 7/35: [GOOD_07] FF (Standard Resistor Corner), V=0.81V, T=-7.0C, pvtp=14, pvtn=14 ---
printf("\n>>> Running Sim 7/35: GOOD_07 (FF, ff_res_bip_dio_disres) V=0.81V, T=-7.0C <<<\n")
desVar("tem" -7.0)
desVar("vreg" 0.81)
temp(-7.0)
desVar("pvt0" 0)
desVar("pvt1" 1)
desVar("pvt2" 1)
desVar("pvt3" 1)
desVar("pvt4" 0)
desVar("pvt5" 0)
desVar("pvt6" 0)
desVar("pvt7" 0)
desVar("pvt8" 0)
desVar("pvt9" 0)
desVar("pvt10" 0)
desVar("pvt11" 0)
desVar("pvt12" 0)
desVar("pvt13" 0)
desVar("pvtn0" 0)
desVar("pvtn1" 1)
desVar("pvtn2" 1)
desVar("pvtn3" 1)
desVar("pvtn4" 0)
desVar("pvtn5" 0)
desVar("pvtn6" 0)
desVar("pvtn7" 0)
desVar("pvtn8" 0)
desVar("pvtn9" 0)
desVar("pvtn10" 0)
desVar("pvtn11" 0)
desVar("pvtn12" 0)
desVar("pvtn13" 0)
run()
selectResults('tran)
pup_val = average((clip((v("/vdd" ?result "tran") - v("/outn" ?result "tran")) 2e-07 2.5e-07) / clip(i("/xdrv_p/out" ?result "tran") 2e-07 2.5e-07)))
pdn_val = (average((clip(v("/outp" ?result "tran") 2e-07 2.5e-07) / clip(i("/xdrv_p/out" ?result "tran") 2e-07 2.5e-07))) * -1)
fprintf(out_file "GOOD_07,FF,Standard Resistor Corner,ff_res_bip_dio_disres,0.81,-7.0,282846140,14,14,%f,%f,49.66,49.51\n" pup_val pdn_val)
drain(out_file)
printf("Result GOOD_07 -> pup=%f, pdn=%f (Target: pup=49.66, pdn=49.51)\n" pup_val pdn_val)

; --- Sim 8/35: [GOOD_08] FF (Standard Resistor Corner), V=0.99V, T=25.5C, pvtp=13, pvtn=13 ---
printf("\n>>> Running Sim 8/35: GOOD_08 (FF, ff_res_bip_dio_disres) V=0.99V, T=25.5C <<<\n")
desVar("tem" 25.5)
desVar("vreg" 0.99)
temp(25.5)
desVar("pvt0" 1)
desVar("pvt1" 0)
desVar("pvt2" 1)
desVar("pvt3" 1)
desVar("pvt4" 0)
desVar("pvt5" 0)
desVar("pvt6" 0)
desVar("pvt7" 0)
desVar("pvt8" 0)
desVar("pvt9" 0)
desVar("pvt10" 0)
desVar("pvt11" 0)
desVar("pvt12" 0)
desVar("pvt13" 0)
desVar("pvtn0" 1)
desVar("pvtn1" 0)
desVar("pvtn2" 1)
desVar("pvtn3" 1)
desVar("pvtn4" 0)
desVar("pvtn5" 0)
desVar("pvtn6" 0)
desVar("pvtn7" 0)
desVar("pvtn8" 0)
desVar("pvtn9" 0)
desVar("pvtn10" 0)
desVar("pvtn11" 0)
desVar("pvtn12" 0)
desVar("pvtn13" 0)
run()
selectResults('tran)
pup_val = average((clip((v("/vdd" ?result "tran") - v("/outn" ?result "tran")) 2e-07 2.5e-07) / clip(i("/xdrv_p/out" ?result "tran") 2e-07 2.5e-07)))
pdn_val = (average((clip(v("/outp" ?result "tran") 2e-07 2.5e-07) / clip(i("/xdrv_p/out" ?result "tran") 2e-07 2.5e-07))) * -1)
fprintf(out_file "GOOD_08,FF,Standard Resistor Corner,ff_res_bip_dio_disres,0.99,25.5,395097330,13,13,%f,%f,50.44,50.47\n" pup_val pdn_val)
drain(out_file)
printf("Result GOOD_08 -> pup=%f, pdn=%f (Target: pup=50.44, pdn=50.47)\n" pup_val pdn_val)

; --- Sim 9/35: [GOOD_09] FF (Standard Resistor Corner), V=0.95V, T=59.0C, pvtp=14, pvtn=14 ---
printf("\n>>> Running Sim 9/35: GOOD_09 (FF, ff_res_bip_dio_disres) V=0.95V, T=59.0C <<<\n")
desVar("tem" 59.0)
desVar("vreg" 0.95)
temp(59.0)
desVar("pvt0" 0)
desVar("pvt1" 1)
desVar("pvt2" 1)
desVar("pvt3" 1)
desVar("pvt4" 0)
desVar("pvt5" 0)
desVar("pvt6" 0)
desVar("pvt7" 0)
desVar("pvt8" 0)
desVar("pvt9" 0)
desVar("pvt10" 0)
desVar("pvt11" 0)
desVar("pvt12" 0)
desVar("pvt13" 0)
desVar("pvtn0" 0)
desVar("pvtn1" 1)
desVar("pvtn2" 1)
desVar("pvtn3" 1)
desVar("pvtn4" 0)
desVar("pvtn5" 0)
desVar("pvtn6" 0)
desVar("pvtn7" 0)
desVar("pvtn8" 0)
desVar("pvtn9" 0)
desVar("pvtn10" 0)
desVar("pvtn11" 0)
desVar("pvtn12" 0)
desVar("pvtn13" 0)
run()
selectResults('tran)
pup_val = average((clip((v("/vdd" ?result "tran") - v("/outn" ?result "tran")) 2e-07 2.5e-07) / clip(i("/xdrv_p/out" ?result "tran") 2e-07 2.5e-07)))
pdn_val = (average((clip(v("/outp" ?result "tran") 2e-07 2.5e-07) / clip(i("/xdrv_p/out" ?result "tran") 2e-07 2.5e-07))) * -1)
fprintf(out_file "GOOD_09,FF,Standard Resistor Corner,ff_res_bip_dio_disres,0.95,59.0,358271050,14,14,%f,%f,50.37,49.87\n" pup_val pdn_val)
drain(out_file)
printf("Result GOOD_09 -> pup=%f, pdn=%f (Target: pup=50.37, pdn=49.87)\n" pup_val pdn_val)

; --- Sim 10/35: [GOOD_10] FF (Standard Resistor Corner), V=0.99V, T=125.0C, pvtp=15, pvtn=15 ---
printf("\n>>> Running Sim 10/35: GOOD_10 (FF, ff_res_bip_dio_disres) V=0.99V, T=125.0C <<<\n")
desVar("tem" 125.0)
desVar("vreg" 0.99)
temp(125.0)
desVar("pvt0" 1)
desVar("pvt1" 1)
desVar("pvt2" 1)
desVar("pvt3" 1)
desVar("pvt4" 0)
desVar("pvt5" 0)
desVar("pvt6" 0)
desVar("pvt7" 0)
desVar("pvt8" 0)
desVar("pvt9" 0)
desVar("pvt10" 0)
desVar("pvt11" 0)
desVar("pvt12" 0)
desVar("pvt13" 0)
desVar("pvtn0" 1)
desVar("pvtn1" 1)
desVar("pvtn2" 1)
desVar("pvtn3" 1)
desVar("pvtn4" 0)
desVar("pvtn5" 0)
desVar("pvtn6" 0)
desVar("pvtn7" 0)
desVar("pvtn8" 0)
desVar("pvtn9" 0)
desVar("pvtn10" 0)
desVar("pvtn11" 0)
desVar("pvtn12" 0)
desVar("pvtn13" 0)
run()
selectResults('tran)
pup_val = average((clip((v("/vdd" ?result "tran") - v("/outn" ?result "tran")) 2e-07 2.5e-07) / clip(i("/xdrv_p/out" ?result "tran") 2e-07 2.5e-07)))
pdn_val = (average((clip(v("/outp" ?result "tran") 2e-07 2.5e-07) / clip(i("/xdrv_p/out" ?result "tran") 2e-07 2.5e-07))) * -1)
fprintf(out_file "GOOD_10,FF,Standard Resistor Corner,ff_res_bip_dio_disres,0.99,125.0,357828760,15,15,%f,%f,51.87,49.77\n" pup_val pdn_val)
drain(out_file)
printf("Result GOOD_10 -> pup=%f, pdn=%f (Target: pup=51.87, pdn=49.77)\n" pup_val pdn_val)

; --- Sim 11/35: [GOOD_11] SS (Standard Resistor Corner), V=0.81V, T=-40.0C, pvtp=249, pvtn=248 ---
modelFile(
    '("/data/cad/pdk_all/pdk_tsmc/pdk_tsmc_28/PDK/TSMC_new_iPDK/models/spectre/crn28hpcp_1d8_elk_v1d0_2p2_shrink0d9_embedded_usage.scs" "ssmacro_mos_moscap")
    '("/data/cad/pdk_all/pdk_tsmc/pdk_tsmc_28/PDK/TSMC_new_iPDK/models/spectre/crn28hpcp_1d8_elk_v1d0_2p2_shrink0d9_embedded_usage.scs" "ss_res_bip_dio_disres")
    '("/data/cad/pdk_all/pdk_tsmc/pdk_tsmc_28/PDK/TSMC_new_iPDK/models/spectre/crn28hpcp_1d8_elk_v1d0_2p2_shrink0d9_embedded_usage.scs" "pre_simu")
)
printf("\n>>> Running Sim 11/35: GOOD_11 (SS, ss_res_bip_dio_disres) V=0.81V, T=-40.0C <<<\n")
desVar("tem" -40.0)
desVar("vreg" 0.81)
temp(-40.0)
desVar("pvt0" 1)
desVar("pvt1" 0)
desVar("pvt2" 0)
desVar("pvt3" 1)
desVar("pvt4" 1)
desVar("pvt5" 1)
desVar("pvt6" 1)
desVar("pvt7" 1)
desVar("pvt8" 0)
desVar("pvt9" 0)
desVar("pvt10" 0)
desVar("pvt11" 0)
desVar("pvt12" 0)
desVar("pvt13" 0)
desVar("pvtn0" 0)
desVar("pvtn1" 0)
desVar("pvtn2" 0)
desVar("pvtn3" 1)
desVar("pvtn4" 1)
desVar("pvtn5" 1)
desVar("pvtn6" 1)
desVar("pvtn7" 1)
desVar("pvtn8" 0)
desVar("pvtn9" 0)
desVar("pvtn10" 0)
desVar("pvtn11" 0)
desVar("pvtn12" 0)
desVar("pvtn13" 0)
run()
selectResults('tran)
pup_val = average((clip((v("/vdd" ?result "tran") - v("/outn" ?result "tran")) 2e-07 2.5e-07) / clip(i("/xdrv_p/out" ?result "tran") 2e-07 2.5e-07)))
pdn_val = (average((clip(v("/outp" ?result "tran") 2e-07 2.5e-07) / clip(i("/xdrv_p/out" ?result "tran") 2e-07 2.5e-07))) * -1)
fprintf(out_file "GOOD_11,SS,Standard Resistor Corner,ss_res_bip_dio_disres,0.81,-40.0,212091500,249,248,%f,%f,49.72,50.15\n" pup_val pdn_val)
drain(out_file)
printf("Result GOOD_11 -> pup=%f, pdn=%f (Target: pup=49.72, pdn=50.15)\n" pup_val pdn_val)

; --- Sim 12/35: [GOOD_12] SS (Standard Resistor Corner), V=0.99V, T=-7.5C, pvtp=243, pvtn=243 ---
printf("\n>>> Running Sim 12/35: GOOD_12 (SS, ss_res_bip_dio_disres) V=0.99V, T=-7.5C <<<\n")
desVar("tem" -7.5)
desVar("vreg" 0.99)
temp(-7.5)
desVar("pvt0" 1)
desVar("pvt1" 1)
desVar("pvt2" 0)
desVar("pvt3" 0)
desVar("pvt4" 1)
desVar("pvt5" 1)
desVar("pvt6" 1)
desVar("pvt7" 1)
desVar("pvt8" 0)
desVar("pvt9" 0)
desVar("pvt10" 0)
desVar("pvt11" 0)
desVar("pvt12" 0)
desVar("pvt13" 0)
desVar("pvtn0" 1)
desVar("pvtn1" 1)
desVar("pvtn2" 0)
desVar("pvtn3" 0)
desVar("pvtn4" 1)
desVar("pvtn5" 1)
desVar("pvtn6" 1)
desVar("pvtn7" 1)
desVar("pvtn8" 0)
desVar("pvtn9" 0)
desVar("pvtn10" 0)
desVar("pvtn11" 0)
desVar("pvtn12" 0)
desVar("pvtn13" 0)
run()
selectResults('tran)
pup_val = average((clip((v("/vdd" ?result "tran") - v("/outn" ?result "tran")) 2e-07 2.5e-07) / clip(i("/xdrv_p/out" ?result "tran") 2e-07 2.5e-07)))
pdn_val = (average((clip(v("/outp" ?result "tran") 2e-07 2.5e-07) / clip(i("/xdrv_p/out" ?result "tran") 2e-07 2.5e-07))) * -1)
fprintf(out_file "GOOD_12,SS,Standard Resistor Corner,ss_res_bip_dio_disres,0.99,-7.5,331344310,243,243,%f,%f,50.05,49.97\n" pup_val pdn_val)
drain(out_file)
printf("Result GOOD_12 -> pup=%f, pdn=%f (Target: pup=50.05, pdn=49.97)\n" pup_val pdn_val)

; --- Sim 13/35: [GOOD_13] SS (Standard Resistor Corner), V=0.97V, T=25.5C, pvtp=248, pvtn=248 ---
printf("\n>>> Running Sim 13/35: GOOD_13 (SS, ss_res_bip_dio_disres) V=0.97V, T=25.5C <<<\n")
desVar("tem" 25.5)
desVar("vreg" 0.97)
temp(25.5)
desVar("pvt0" 0)
desVar("pvt1" 0)
desVar("pvt2" 0)
desVar("pvt3" 1)
desVar("pvt4" 1)
desVar("pvt5" 1)
desVar("pvt6" 1)
desVar("pvt7" 1)
desVar("pvt8" 0)
desVar("pvt9" 0)
desVar("pvt10" 0)
desVar("pvt11" 0)
desVar("pvt12" 0)
desVar("pvt13" 0)
desVar("pvtn0" 0)
desVar("pvtn1" 0)
desVar("pvtn2" 0)
desVar("pvtn3" 1)
desVar("pvtn4" 1)
desVar("pvtn5" 1)
desVar("pvtn6" 1)
desVar("pvtn7" 1)
desVar("pvtn8" 0)
desVar("pvtn9" 0)
desVar("pvtn10" 0)
desVar("pvtn11" 0)
desVar("pvtn12" 0)
desVar("pvtn13" 0)
run()
selectResults('tran)
pup_val = average((clip((v("/vdd" ?result "tran") - v("/outn" ?result "tran")) 2e-07 2.5e-07) / clip(i("/xdrv_p/out" ?result "tran") 2e-07 2.5e-07)))
pdn_val = (average((clip(v("/outp" ?result "tran") 2e-07 2.5e-07) / clip(i("/xdrv_p/out" ?result "tran") 2e-07 2.5e-07))) * -1)
fprintf(out_file "GOOD_13,SS,Standard Resistor Corner,ss_res_bip_dio_disres,0.97,25.5,307613840,248,248,%f,%f,50.02,49.92\n" pup_val pdn_val)
drain(out_file)
printf("Result GOOD_13 -> pup=%f, pdn=%f (Target: pup=50.02, pdn=49.92)\n" pup_val pdn_val)

; --- Sim 14/35: [GOOD_14] SS (Standard Resistor Corner), V=0.99V, T=59.0C, pvtp=249, pvtn=248 ---
printf("\n>>> Running Sim 14/35: GOOD_14 (SS, ss_res_bip_dio_disres) V=0.99V, T=59.0C <<<\n")
desVar("tem" 59.0)
desVar("vreg" 0.99)
temp(59.0)
desVar("pvt0" 1)
desVar("pvt1" 0)
desVar("pvt2" 0)
desVar("pvt3" 1)
desVar("pvt4" 1)
desVar("pvt5" 1)
desVar("pvt6" 1)
desVar("pvt7" 1)
desVar("pvt8" 0)
desVar("pvt9" 0)
desVar("pvt10" 0)
desVar("pvt11" 0)
desVar("pvt12" 0)
desVar("pvt13" 0)
desVar("pvtn0" 0)
desVar("pvtn1" 0)
desVar("pvtn2" 0)
desVar("pvtn3" 1)
desVar("pvtn4" 1)
desVar("pvtn5" 1)
desVar("pvtn6" 1)
desVar("pvtn7" 1)
desVar("pvtn8" 0)
desVar("pvtn9" 0)
desVar("pvtn10" 0)
desVar("pvtn11" 0)
desVar("pvtn12" 0)
desVar("pvtn13" 0)
run()
selectResults('tran)
pup_val = average((clip((v("/vdd" ?result "tran") - v("/outn" ?result "tran")) 2e-07 2.5e-07) / clip(i("/xdrv_p/out" ?result "tran") 2e-07 2.5e-07)))
pdn_val = (average((clip(v("/outp" ?result "tran") 2e-07 2.5e-07) / clip(i("/xdrv_p/out" ?result "tran") 2e-07 2.5e-07))) * -1)
fprintf(out_file "GOOD_14,SS,Standard Resistor Corner,ss_res_bip_dio_disres,0.99,59.0,308727260,249,248,%f,%f,49.63,50.54\n" pup_val pdn_val)
drain(out_file)
printf("Result GOOD_14 -> pup=%f, pdn=%f (Target: pup=49.63, pdn=50.54)\n" pup_val pdn_val)

; --- Sim 15/35: [GOOD_15] SS (Standard Resistor Corner), V=0.99V, T=125.0C, pvtp=250, pvtn=250 ---
printf("\n>>> Running Sim 15/35: GOOD_15 (SS, ss_res_bip_dio_disres) V=0.99V, T=125.0C <<<\n")
desVar("tem" 125.0)
desVar("vreg" 0.99)
temp(125.0)
desVar("pvt0" 0)
desVar("pvt1" 1)
desVar("pvt2" 0)
desVar("pvt3" 1)
desVar("pvt4" 1)
desVar("pvt5" 1)
desVar("pvt6" 1)
desVar("pvt7" 1)
desVar("pvt8" 0)
desVar("pvt9" 0)
desVar("pvt10" 0)
desVar("pvt11" 0)
desVar("pvt12" 0)
desVar("pvt13" 0)
desVar("pvtn0" 0)
desVar("pvtn1" 1)
desVar("pvtn2" 0)
desVar("pvtn3" 1)
desVar("pvtn4" 1)
desVar("pvtn5" 1)
desVar("pvtn6" 1)
desVar("pvtn7" 1)
desVar("pvtn8" 0)
desVar("pvtn9" 0)
desVar("pvtn10" 0)
desVar("pvtn11" 0)
desVar("pvtn12" 0)
desVar("pvtn13" 0)
run()
selectResults('tran)
pup_val = average((clip((v("/vdd" ?result "tran") - v("/outn" ?result "tran")) 2e-07 2.5e-07) / clip(i("/xdrv_p/out" ?result "tran") 2e-07 2.5e-07)))
pdn_val = (average((clip(v("/outp" ?result "tran") 2e-07 2.5e-07) / clip(i("/xdrv_p/out" ?result "tran") 2e-07 2.5e-07))) * -1)
fprintf(out_file "GOOD_15,SS,Standard Resistor Corner,ss_res_bip_dio_disres,0.99,125.0,293837330,250,250,%f,%f,50.42,49.71\n" pup_val pdn_val)
drain(out_file)
printf("Result GOOD_15 -> pup=%f, pdn=%f (Target: pup=50.42, pdn=49.71)\n" pup_val pdn_val)

; --- Sim 16/35: [GOOD_16] FS (FS Cross Option 1 (FF Res)), V=0.81V, T=-40.0C, pvtp=28, pvtn=14 ---
modelFile(
    '("/data/cad/pdk_all/pdk_tsmc/pdk_tsmc_28/PDK/TSMC_new_iPDK/models/spectre/crn28hpcp_1d8_elk_v1d0_2p2_shrink0d9_embedded_usage.scs" "fsmacro_mos_moscap")
    '("/data/cad/pdk_all/pdk_tsmc/pdk_tsmc_28/PDK/TSMC_new_iPDK/models/spectre/crn28hpcp_1d8_elk_v1d0_2p2_shrink0d9_embedded_usage.scs" "ff_res_bip_dio_disres")
    '("/data/cad/pdk_all/pdk_tsmc/pdk_tsmc_28/PDK/TSMC_new_iPDK/models/spectre/crn28hpcp_1d8_elk_v1d0_2p2_shrink0d9_embedded_usage.scs" "pre_simu")
)
printf("\n>>> Running Sim 16/35: GOOD_16 (FS, ff_res_bip_dio_disres) V=0.81V, T=-40.0C <<<\n")
desVar("tem" -40.0)
desVar("vreg" 0.81)
temp(-40.0)
desVar("pvt0" 0)
desVar("pvt1" 0)
desVar("pvt2" 1)
desVar("pvt3" 1)
desVar("pvt4" 1)
desVar("pvt5" 0)
desVar("pvt6" 0)
desVar("pvt7" 0)
desVar("pvt8" 0)
desVar("pvt9" 0)
desVar("pvt10" 0)
desVar("pvt11" 0)
desVar("pvt12" 0)
desVar("pvt13" 0)
desVar("pvtn0" 0)
desVar("pvtn1" 1)
desVar("pvtn2" 1)
desVar("pvtn3" 1)
desVar("pvtn4" 0)
desVar("pvtn5" 0)
desVar("pvtn6" 0)
desVar("pvtn7" 0)
desVar("pvtn8" 0)
desVar("pvtn9" 0)
desVar("pvtn10" 0)
desVar("pvtn11" 0)
desVar("pvtn12" 0)
desVar("pvtn13" 0)
run()
selectResults('tran)
pup_val = average((clip((v("/vdd" ?result "tran") - v("/outn" ?result "tran")) 2e-07 2.5e-07) / clip(i("/xdrv_p/out" ?result "tran") 2e-07 2.5e-07)))
pdn_val = (average((clip(v("/outp" ?result "tran") 2e-07 2.5e-07) / clip(i("/xdrv_p/out" ?result "tran") 2e-07 2.5e-07))) * -1)
fprintf(out_file "GOOD_16,FS,FS Cross Option 1 (FF Res),ff_res_bip_dio_disres,0.81,-40.0,253705610,28,14,%f,%f,49.628,49.02\n" pup_val pdn_val)
drain(out_file)
printf("Result GOOD_16 -> pup=%f, pdn=%f (Target: pup=49.628, pdn=49.02)\n" pup_val pdn_val)

; --- Sim 17/35: [GOOD_17] FS (FS Cross Option 1 (FF Res)), V=0.81V, T=-11.5C, pvtp=28, pvtn=14 ---
printf("\n>>> Running Sim 17/35: GOOD_17 (FS, ff_res_bip_dio_disres) V=0.81V, T=-11.5C <<<\n")
desVar("tem" -11.5)
desVar("vreg" 0.81)
temp(-11.5)
desVar("pvt0" 0)
desVar("pvt1" 0)
desVar("pvt2" 1)
desVar("pvt3" 1)
desVar("pvt4" 1)
desVar("pvt5" 0)
desVar("pvt6" 0)
desVar("pvt7" 0)
desVar("pvt8" 0)
desVar("pvt9" 0)
desVar("pvt10" 0)
desVar("pvt11" 0)
desVar("pvt12" 0)
desVar("pvt13" 0)
desVar("pvtn0" 0)
desVar("pvtn1" 1)
desVar("pvtn2" 1)
desVar("pvtn3" 1)
desVar("pvtn4" 0)
desVar("pvtn5" 0)
desVar("pvtn6" 0)
desVar("pvtn7" 0)
desVar("pvtn8" 0)
desVar("pvtn9" 0)
desVar("pvtn10" 0)
desVar("pvtn11" 0)
desVar("pvtn12" 0)
desVar("pvtn13" 0)
run()
selectResults('tran)
pup_val = average((clip((v("/vdd" ?result "tran") - v("/outn" ?result "tran")) 2e-07 2.5e-07) / clip(i("/xdrv_p/out" ?result "tran") 2e-07 2.5e-07)))
pdn_val = (average((clip(v("/outp" ?result "tran") 2e-07 2.5e-07) / clip(i("/xdrv_p/out" ?result "tran") 2e-07 2.5e-07))) * -1)
fprintf(out_file "GOOD_17,FS,FS Cross Option 1 (FF Res),ff_res_bip_dio_disres,0.81,-11.5,250502300,28,14,%f,%f,50.504,49.73\n" pup_val pdn_val)
drain(out_file)
printf("Result GOOD_17 -> pup=%f, pdn=%f (Target: pup=50.504, pdn=49.73)\n" pup_val pdn_val)

; --- Sim 18/35: [GOOD_18] FS (FS Cross Option 1 (FF Res)), V=0.93V, T=25.0C, pvtp=28, pvtn=13 ---
printf("\n>>> Running Sim 18/35: GOOD_18 (FS, ff_res_bip_dio_disres) V=0.93V, T=25.0C <<<\n")
desVar("tem" 25.0)
desVar("vreg" 0.93)
temp(25.0)
desVar("pvt0" 0)
desVar("pvt1" 0)
desVar("pvt2" 1)
desVar("pvt3" 1)
desVar("pvt4" 1)
desVar("pvt5" 0)
desVar("pvt6" 0)
desVar("pvt7" 0)
desVar("pvt8" 0)
desVar("pvt9" 0)
desVar("pvt10" 0)
desVar("pvt11" 0)
desVar("pvt12" 0)
desVar("pvt13" 0)
desVar("pvtn0" 1)
desVar("pvtn1" 0)
desVar("pvtn2" 1)
desVar("pvtn3" 1)
desVar("pvtn4" 0)
desVar("pvtn5" 0)
desVar("pvtn6" 0)
desVar("pvtn7" 0)
desVar("pvtn8" 0)
desVar("pvtn9" 0)
desVar("pvtn10" 0)
desVar("pvtn11" 0)
desVar("pvtn12" 0)
desVar("pvtn13" 0)
run()
selectResults('tran)
pup_val = average((clip((v("/vdd" ?result "tran") - v("/outn" ?result "tran")) 2e-07 2.5e-07) / clip(i("/xdrv_p/out" ?result "tran") 2e-07 2.5e-07)))
pdn_val = (average((clip(v("/outp" ?result "tran") 2e-07 2.5e-07) / clip(i("/xdrv_p/out" ?result "tran") 2e-07 2.5e-07))) * -1)
fprintf(out_file "GOOD_18,FS,FS Cross Option 1 (FF Res),ff_res_bip_dio_disres,0.93,25.0,331170490,28,13,%f,%f,49.177,51.08\n" pup_val pdn_val)
drain(out_file)
printf("Result GOOD_18 -> pup=%f, pdn=%f (Target: pup=49.177, pdn=51.08)\n" pup_val pdn_val)

; --- Sim 19/35: [GOOD_19] FS (FS Cross Option 1 (FF Res)), V=0.95V, T=55.0C, pvtp=28, pvtn=14 ---
printf("\n>>> Running Sim 19/35: GOOD_19 (FS, ff_res_bip_dio_disres) V=0.95V, T=55.0C <<<\n")
desVar("tem" 55.0)
desVar("vreg" 0.95)
temp(55.0)
desVar("pvt0" 0)
desVar("pvt1" 0)
desVar("pvt2" 1)
desVar("pvt3" 1)
desVar("pvt4" 1)
desVar("pvt5" 0)
desVar("pvt6" 0)
desVar("pvt7" 0)
desVar("pvt8" 0)
desVar("pvt9" 0)
desVar("pvt10" 0)
desVar("pvt11" 0)
desVar("pvt12" 0)
desVar("pvt13" 0)
desVar("pvtn0" 0)
desVar("pvtn1" 1)
desVar("pvtn2" 1)
desVar("pvtn3" 1)
desVar("pvtn4" 0)
desVar("pvtn5" 0)
desVar("pvtn6" 0)
desVar("pvtn7" 0)
desVar("pvtn8" 0)
desVar("pvtn9" 0)
desVar("pvtn10" 0)
desVar("pvtn11" 0)
desVar("pvtn12" 0)
desVar("pvtn13" 0)
run()
selectResults('tran)
pup_val = average((clip((v("/vdd" ?result "tran") - v("/outn" ?result "tran")) 2e-07 2.5e-07) / clip(i("/xdrv_p/out" ?result "tran") 2e-07 2.5e-07)))
pdn_val = (average((clip(v("/outp" ?result "tran") 2e-07 2.5e-07) / clip(i("/xdrv_p/out" ?result "tran") 2e-07 2.5e-07))) * -1)
fprintf(out_file "GOOD_19,FS,FS Cross Option 1 (FF Res),ff_res_bip_dio_disres,0.95,55.0,334869190,28,14,%f,%f,50.002,49.98\n" pup_val pdn_val)
drain(out_file)
printf("Result GOOD_19 -> pup=%f, pdn=%f (Target: pup=50.002, pdn=49.98)\n" pup_val pdn_val)

; --- Sim 20/35: [GOOD_20] FS (FS Cross Option 1 (FF Res)), V=0.99V, T=125.0C, pvtp=29, pvtn=14 ---
printf("\n>>> Running Sim 20/35: GOOD_20 (FS, ff_res_bip_dio_disres) V=0.99V, T=125.0C <<<\n")
desVar("tem" 125.0)
desVar("vreg" 0.99)
temp(125.0)
desVar("pvt0" 1)
desVar("pvt1" 0)
desVar("pvt2" 1)
desVar("pvt3" 1)
desVar("pvt4" 1)
desVar("pvt5" 0)
desVar("pvt6" 0)
desVar("pvt7" 0)
desVar("pvt8" 0)
desVar("pvt9" 0)
desVar("pvt10" 0)
desVar("pvt11" 0)
desVar("pvt12" 0)
desVar("pvt13" 0)
desVar("pvtn0" 0)
desVar("pvtn1" 1)
desVar("pvtn2" 1)
desVar("pvtn3" 1)
desVar("pvtn4" 0)
desVar("pvtn5" 0)
desVar("pvtn6" 0)
desVar("pvtn7" 0)
desVar("pvtn8" 0)
desVar("pvtn9" 0)
desVar("pvtn10" 0)
desVar("pvtn11" 0)
desVar("pvtn12" 0)
desVar("pvtn13" 0)
run()
selectResults('tran)
pup_val = average((clip((v("/vdd" ?result "tran") - v("/outn" ?result "tran")) 2e-07 2.5e-07) / clip(i("/xdrv_p/out" ?result "tran") 2e-07 2.5e-07)))
pdn_val = (average((clip(v("/outp" ?result "tran") 2e-07 2.5e-07) / clip(i("/xdrv_p/out" ?result "tran") 2e-07 2.5e-07))) * -1)
fprintf(out_file "GOOD_20,FS,FS Cross Option 1 (FF Res),ff_res_bip_dio_disres,0.99,125.0,338001700,29,14,%f,%f,51.628,50.99\n" pup_val pdn_val)
drain(out_file)
printf("Result GOOD_20 -> pup=%f, pdn=%f (Target: pup=51.628, pdn=50.99)\n" pup_val pdn_val)

; --- Sim 21/35: [GOOD_21] FS (FS Cross Option 2 (SS Res)), V=0.81V, T=-40.0C, pvtp=28, pvtn=14 ---
modelFile(
    '("/data/cad/pdk_all/pdk_tsmc/pdk_tsmc_28/PDK/TSMC_new_iPDK/models/spectre/crn28hpcp_1d8_elk_v1d0_2p2_shrink0d9_embedded_usage.scs" "fsmacro_mos_moscap")
    '("/data/cad/pdk_all/pdk_tsmc/pdk_tsmc_28/PDK/TSMC_new_iPDK/models/spectre/crn28hpcp_1d8_elk_v1d0_2p2_shrink0d9_embedded_usage.scs" "ss_res_bip_dio_disres")
    '("/data/cad/pdk_all/pdk_tsmc/pdk_tsmc_28/PDK/TSMC_new_iPDK/models/spectre/crn28hpcp_1d8_elk_v1d0_2p2_shrink0d9_embedded_usage.scs" "pre_simu")
)
printf("\n>>> Running Sim 21/35: GOOD_21 (FS, ss_res_bip_dio_disres) V=0.81V, T=-40.0C <<<\n")
desVar("tem" -40.0)
desVar("vreg" 0.81)
temp(-40.0)
desVar("pvt0" 0)
desVar("pvt1" 0)
desVar("pvt2" 1)
desVar("pvt3" 1)
desVar("pvt4" 1)
desVar("pvt5" 0)
desVar("pvt6" 0)
desVar("pvt7" 0)
desVar("pvt8" 0)
desVar("pvt9" 0)
desVar("pvt10" 0)
desVar("pvt11" 0)
desVar("pvt12" 0)
desVar("pvt13" 0)
desVar("pvtn0" 0)
desVar("pvtn1" 1)
desVar("pvtn2" 1)
desVar("pvtn3" 1)
desVar("pvtn4" 0)
desVar("pvtn5" 0)
desVar("pvtn6" 0)
desVar("pvtn7" 0)
desVar("pvtn8" 0)
desVar("pvtn9" 0)
desVar("pvtn10" 0)
desVar("pvtn11" 0)
desVar("pvtn12" 0)
desVar("pvtn13" 0)
run()
selectResults('tran)
pup_val = average((clip((v("/vdd" ?result "tran") - v("/outn" ?result "tran")) 2e-07 2.5e-07) / clip(i("/xdrv_p/out" ?result "tran") 2e-07 2.5e-07)))
pdn_val = (average((clip(v("/outp" ?result "tran") 2e-07 2.5e-07) / clip(i("/xdrv_p/out" ?result "tran") 2e-07 2.5e-07))) * -1)
fprintf(out_file "GOOD_21,FS,FS Cross Option 2 (SS Res),ss_res_bip_dio_disres,0.81,-40.0,253705610,28,14,%f,%f,49.628,49.02\n" pup_val pdn_val)
drain(out_file)
printf("Result GOOD_21 -> pup=%f, pdn=%f (Target: pup=49.628, pdn=49.02)\n" pup_val pdn_val)

; --- Sim 22/35: [GOOD_22] FS (FS Cross Option 2 (SS Res)), V=0.81V, T=-11.5C, pvtp=28, pvtn=14 ---
printf("\n>>> Running Sim 22/35: GOOD_22 (FS, ss_res_bip_dio_disres) V=0.81V, T=-11.5C <<<\n")
desVar("tem" -11.5)
desVar("vreg" 0.81)
temp(-11.5)
desVar("pvt0" 0)
desVar("pvt1" 0)
desVar("pvt2" 1)
desVar("pvt3" 1)
desVar("pvt4" 1)
desVar("pvt5" 0)
desVar("pvt6" 0)
desVar("pvt7" 0)
desVar("pvt8" 0)
desVar("pvt9" 0)
desVar("pvt10" 0)
desVar("pvt11" 0)
desVar("pvt12" 0)
desVar("pvt13" 0)
desVar("pvtn0" 0)
desVar("pvtn1" 1)
desVar("pvtn2" 1)
desVar("pvtn3" 1)
desVar("pvtn4" 0)
desVar("pvtn5" 0)
desVar("pvtn6" 0)
desVar("pvtn7" 0)
desVar("pvtn8" 0)
desVar("pvtn9" 0)
desVar("pvtn10" 0)
desVar("pvtn11" 0)
desVar("pvtn12" 0)
desVar("pvtn13" 0)
run()
selectResults('tran)
pup_val = average((clip((v("/vdd" ?result "tran") - v("/outn" ?result "tran")) 2e-07 2.5e-07) / clip(i("/xdrv_p/out" ?result "tran") 2e-07 2.5e-07)))
pdn_val = (average((clip(v("/outp" ?result "tran") 2e-07 2.5e-07) / clip(i("/xdrv_p/out" ?result "tran") 2e-07 2.5e-07))) * -1)
fprintf(out_file "GOOD_22,FS,FS Cross Option 2 (SS Res),ss_res_bip_dio_disres,0.81,-11.5,250502300,28,14,%f,%f,50.504,49.73\n" pup_val pdn_val)
drain(out_file)
printf("Result GOOD_22 -> pup=%f, pdn=%f (Target: pup=50.504, pdn=49.73)\n" pup_val pdn_val)

; --- Sim 23/35: [GOOD_23] FS (FS Cross Option 2 (SS Res)), V=0.93V, T=25.0C, pvtp=28, pvtn=13 ---
printf("\n>>> Running Sim 23/35: GOOD_23 (FS, ss_res_bip_dio_disres) V=0.93V, T=25.0C <<<\n")
desVar("tem" 25.0)
desVar("vreg" 0.93)
temp(25.0)
desVar("pvt0" 0)
desVar("pvt1" 0)
desVar("pvt2" 1)
desVar("pvt3" 1)
desVar("pvt4" 1)
desVar("pvt5" 0)
desVar("pvt6" 0)
desVar("pvt7" 0)
desVar("pvt8" 0)
desVar("pvt9" 0)
desVar("pvt10" 0)
desVar("pvt11" 0)
desVar("pvt12" 0)
desVar("pvt13" 0)
desVar("pvtn0" 1)
desVar("pvtn1" 0)
desVar("pvtn2" 1)
desVar("pvtn3" 1)
desVar("pvtn4" 0)
desVar("pvtn5" 0)
desVar("pvtn6" 0)
desVar("pvtn7" 0)
desVar("pvtn8" 0)
desVar("pvtn9" 0)
desVar("pvtn10" 0)
desVar("pvtn11" 0)
desVar("pvtn12" 0)
desVar("pvtn13" 0)
run()
selectResults('tran)
pup_val = average((clip((v("/vdd" ?result "tran") - v("/outn" ?result "tran")) 2e-07 2.5e-07) / clip(i("/xdrv_p/out" ?result "tran") 2e-07 2.5e-07)))
pdn_val = (average((clip(v("/outp" ?result "tran") 2e-07 2.5e-07) / clip(i("/xdrv_p/out" ?result "tran") 2e-07 2.5e-07))) * -1)
fprintf(out_file "GOOD_23,FS,FS Cross Option 2 (SS Res),ss_res_bip_dio_disres,0.93,25.0,331170490,28,13,%f,%f,49.177,51.08\n" pup_val pdn_val)
drain(out_file)
printf("Result GOOD_23 -> pup=%f, pdn=%f (Target: pup=49.177, pdn=51.08)\n" pup_val pdn_val)

; --- Sim 24/35: [GOOD_24] FS (FS Cross Option 2 (SS Res)), V=0.95V, T=55.0C, pvtp=28, pvtn=14 ---
printf("\n>>> Running Sim 24/35: GOOD_24 (FS, ss_res_bip_dio_disres) V=0.95V, T=55.0C <<<\n")
desVar("tem" 55.0)
desVar("vreg" 0.95)
temp(55.0)
desVar("pvt0" 0)
desVar("pvt1" 0)
desVar("pvt2" 1)
desVar("pvt3" 1)
desVar("pvt4" 1)
desVar("pvt5" 0)
desVar("pvt6" 0)
desVar("pvt7" 0)
desVar("pvt8" 0)
desVar("pvt9" 0)
desVar("pvt10" 0)
desVar("pvt11" 0)
desVar("pvt12" 0)
desVar("pvt13" 0)
desVar("pvtn0" 0)
desVar("pvtn1" 1)
desVar("pvtn2" 1)
desVar("pvtn3" 1)
desVar("pvtn4" 0)
desVar("pvtn5" 0)
desVar("pvtn6" 0)
desVar("pvtn7" 0)
desVar("pvtn8" 0)
desVar("pvtn9" 0)
desVar("pvtn10" 0)
desVar("pvtn11" 0)
desVar("pvtn12" 0)
desVar("pvtn13" 0)
run()
selectResults('tran)
pup_val = average((clip((v("/vdd" ?result "tran") - v("/outn" ?result "tran")) 2e-07 2.5e-07) / clip(i("/xdrv_p/out" ?result "tran") 2e-07 2.5e-07)))
pdn_val = (average((clip(v("/outp" ?result "tran") 2e-07 2.5e-07) / clip(i("/xdrv_p/out" ?result "tran") 2e-07 2.5e-07))) * -1)
fprintf(out_file "GOOD_24,FS,FS Cross Option 2 (SS Res),ss_res_bip_dio_disres,0.95,55.0,334869190,28,14,%f,%f,50.002,49.98\n" pup_val pdn_val)
drain(out_file)
printf("Result GOOD_24 -> pup=%f, pdn=%f (Target: pup=50.002, pdn=49.98)\n" pup_val pdn_val)

; --- Sim 25/35: [GOOD_25] FS (FS Cross Option 2 (SS Res)), V=0.99V, T=125.0C, pvtp=29, pvtn=14 ---
printf("\n>>> Running Sim 25/35: GOOD_25 (FS, ss_res_bip_dio_disres) V=0.99V, T=125.0C <<<\n")
desVar("tem" 125.0)
desVar("vreg" 0.99)
temp(125.0)
desVar("pvt0" 1)
desVar("pvt1" 0)
desVar("pvt2" 1)
desVar("pvt3" 1)
desVar("pvt4" 1)
desVar("pvt5" 0)
desVar("pvt6" 0)
desVar("pvt7" 0)
desVar("pvt8" 0)
desVar("pvt9" 0)
desVar("pvt10" 0)
desVar("pvt11" 0)
desVar("pvt12" 0)
desVar("pvt13" 0)
desVar("pvtn0" 0)
desVar("pvtn1" 1)
desVar("pvtn2" 1)
desVar("pvtn3" 1)
desVar("pvtn4" 0)
desVar("pvtn5" 0)
desVar("pvtn6" 0)
desVar("pvtn7" 0)
desVar("pvtn8" 0)
desVar("pvtn9" 0)
desVar("pvtn10" 0)
desVar("pvtn11" 0)
desVar("pvtn12" 0)
desVar("pvtn13" 0)
run()
selectResults('tran)
pup_val = average((clip((v("/vdd" ?result "tran") - v("/outn" ?result "tran")) 2e-07 2.5e-07) / clip(i("/xdrv_p/out" ?result "tran") 2e-07 2.5e-07)))
pdn_val = (average((clip(v("/outp" ?result "tran") 2e-07 2.5e-07) / clip(i("/xdrv_p/out" ?result "tran") 2e-07 2.5e-07))) * -1)
fprintf(out_file "GOOD_25,FS,FS Cross Option 2 (SS Res),ss_res_bip_dio_disres,0.99,125.0,338001700,29,14,%f,%f,51.628,50.99\n" pup_val pdn_val)
drain(out_file)
printf("Result GOOD_25 -> pup=%f, pdn=%f (Target: pup=51.628, pdn=50.99)\n" pup_val pdn_val)

; --- Sim 26/35: [GOOD_26] SF (SF Cross Option 1 (SS Res)), V=0.81V, T=-40.0C, pvtp=62, pvtn=123 ---
modelFile(
    '("/data/cad/pdk_all/pdk_tsmc/pdk_tsmc_28/PDK/TSMC_new_iPDK/models/spectre/crn28hpcp_1d8_elk_v1d0_2p2_shrink0d9_embedded_usage.scs" "sfmacro_mos_moscap")
    '("/data/cad/pdk_all/pdk_tsmc/pdk_tsmc_28/PDK/TSMC_new_iPDK/models/spectre/crn28hpcp_1d8_elk_v1d0_2p2_shrink0d9_embedded_usage.scs" "ss_res_bip_dio_disres")
    '("/data/cad/pdk_all/pdk_tsmc/pdk_tsmc_28/PDK/TSMC_new_iPDK/models/spectre/crn28hpcp_1d8_elk_v1d0_2p2_shrink0d9_embedded_usage.scs" "pre_simu")
)
printf("\n>>> Running Sim 26/35: GOOD_26 (SF, ss_res_bip_dio_disres) V=0.81V, T=-40.0C <<<\n")
desVar("tem" -40.0)
desVar("vreg" 0.81)
temp(-40.0)
desVar("pvt0" 0)
desVar("pvt1" 1)
desVar("pvt2" 1)
desVar("pvt3" 1)
desVar("pvt4" 1)
desVar("pvt5" 1)
desVar("pvt6" 0)
desVar("pvt7" 0)
desVar("pvt8" 0)
desVar("pvt9" 0)
desVar("pvt10" 0)
desVar("pvt11" 0)
desVar("pvt12" 0)
desVar("pvt13" 0)
desVar("pvtn0" 1)
desVar("pvtn1" 1)
desVar("pvtn2" 0)
desVar("pvtn3" 1)
desVar("pvtn4" 1)
desVar("pvtn5" 1)
desVar("pvtn6" 1)
desVar("pvtn7" 0)
desVar("pvtn8" 0)
desVar("pvtn9" 0)
desVar("pvtn10" 0)
desVar("pvtn11" 0)
desVar("pvtn12" 0)
desVar("pvtn13" 0)
run()
selectResults('tran)
pup_val = average((clip((v("/vdd" ?result "tran") - v("/outn" ?result "tran")) 2e-07 2.5e-07) / clip(i("/xdrv_p/out" ?result "tran") 2e-07 2.5e-07)))
pdn_val = (average((clip(v("/outp" ?result "tran") 2e-07 2.5e-07) / clip(i("/xdrv_p/out" ?result "tran") 2e-07 2.5e-07))) * -1)
fprintf(out_file "GOOD_26,SF,SF Cross Option 1 (SS Res),ss_res_bip_dio_disres,0.81,-40.0,241869650,62,123,%f,%f,50.113,49.848\n" pup_val pdn_val)
drain(out_file)
printf("Result GOOD_26 -> pup=%f, pdn=%f (Target: pup=50.113, pdn=49.848)\n" pup_val pdn_val)

; --- Sim 27/35: [GOOD_27] SF (SF Cross Option 1 (SS Res)), V=0.97V, T=-7.5C, pvtp=122, pvtn=123 ---
printf("\n>>> Running Sim 27/35: GOOD_27 (SF, ss_res_bip_dio_disres) V=0.97V, T=-7.5C <<<\n")
desVar("tem" -7.5)
desVar("vreg" 0.97)
temp(-7.5)
desVar("pvt0" 0)
desVar("pvt1" 1)
desVar("pvt2" 0)
desVar("pvt3" 1)
desVar("pvt4" 1)
desVar("pvt5" 1)
desVar("pvt6" 1)
desVar("pvt7" 0)
desVar("pvt8" 0)
desVar("pvt9" 0)
desVar("pvt10" 0)
desVar("pvt11" 0)
desVar("pvt12" 0)
desVar("pvt13" 0)
desVar("pvtn0" 1)
desVar("pvtn1" 1)
desVar("pvtn2" 0)
desVar("pvtn3" 1)
desVar("pvtn4" 1)
desVar("pvtn5" 1)
desVar("pvtn6" 1)
desVar("pvtn7" 0)
desVar("pvtn8" 0)
desVar("pvtn9" 0)
desVar("pvtn10" 0)
desVar("pvtn11" 0)
desVar("pvtn12" 0)
desVar("pvtn13" 0)
run()
selectResults('tran)
pup_val = average((clip((v("/vdd" ?result "tran") - v("/outn" ?result "tran")) 2e-07 2.5e-07) / clip(i("/xdrv_p/out" ?result "tran") 2e-07 2.5e-07)))
pdn_val = (average((clip(v("/outp" ?result "tran") 2e-07 2.5e-07) / clip(i("/xdrv_p/out" ?result "tran") 2e-07 2.5e-07))) * -1)
fprintf(out_file "GOOD_27,SF,SF Cross Option 1 (SS Res),ss_res_bip_dio_disres,0.97,-7.5,345124630,122,123,%f,%f,49.6,49.95\n" pup_val pdn_val)
drain(out_file)
printf("Result GOOD_27 -> pup=%f, pdn=%f (Target: pup=49.6, pdn=49.95)\n" pup_val pdn_val)

; --- Sim 28/35: [GOOD_28] SF (SF Cross Option 1 (SS Res)), V=0.81V, T=26.0C, pvtp=124, pvtn=125 ---
printf("\n>>> Running Sim 28/35: GOOD_28 (SF, ss_res_bip_dio_disres) V=0.81V, T=26.0C <<<\n")
desVar("tem" 26.0)
desVar("vreg" 0.81)
temp(26.0)
desVar("pvt0" 0)
desVar("pvt1" 0)
desVar("pvt2" 1)
desVar("pvt3" 1)
desVar("pvt4" 1)
desVar("pvt5" 1)
desVar("pvt6" 1)
desVar("pvt7" 0)
desVar("pvt8" 0)
desVar("pvt9" 0)
desVar("pvt10" 0)
desVar("pvt11" 0)
desVar("pvt12" 0)
desVar("pvt13" 0)
desVar("pvtn0" 1)
desVar("pvtn1" 0)
desVar("pvtn2" 1)
desVar("pvtn3" 1)
desVar("pvtn4" 1)
desVar("pvtn5" 1)
desVar("pvtn6" 1)
desVar("pvtn7" 0)
desVar("pvtn8" 0)
desVar("pvtn9" 0)
desVar("pvtn10" 0)
desVar("pvtn11" 0)
desVar("pvtn12" 0)
desVar("pvtn13" 0)
run()
selectResults('tran)
pup_val = average((clip((v("/vdd" ?result "tran") - v("/outn" ?result "tran")) 2e-07 2.5e-07) / clip(i("/xdrv_p/out" ?result "tran") 2e-07 2.5e-07)))
pdn_val = (average((clip(v("/outp" ?result "tran") 2e-07 2.5e-07) / clip(i("/xdrv_p/out" ?result "tran") 2e-07 2.5e-07))) * -1)
fprintf(out_file "GOOD_28,SF,SF Cross Option 1 (SS Res),ss_res_bip_dio_disres,0.81,26.0,233790580,124,125,%f,%f,50.54,50.425\n" pup_val pdn_val)
drain(out_file)
printf("Result GOOD_28 -> pup=%f, pdn=%f (Target: pup=50.54, pdn=50.425)\n" pup_val pdn_val)

; --- Sim 29/35: [GOOD_29] SF (SF Cross Option 1 (SS Res)), V=0.93V, T=59.0C, pvtp=123, pvtn=125 ---
printf("\n>>> Running Sim 29/35: GOOD_29 (SF, ss_res_bip_dio_disres) V=0.93V, T=59.0C <<<\n")
desVar("tem" 59.0)
desVar("vreg" 0.93)
temp(59.0)
desVar("pvt0" 1)
desVar("pvt1" 1)
desVar("pvt2" 0)
desVar("pvt3" 1)
desVar("pvt4" 1)
desVar("pvt5" 1)
desVar("pvt6" 1)
desVar("pvt7" 0)
desVar("pvt8" 0)
desVar("pvt9" 0)
desVar("pvt10" 0)
desVar("pvt11" 0)
desVar("pvt12" 0)
desVar("pvt13" 0)
desVar("pvtn0" 1)
desVar("pvtn1" 0)
desVar("pvtn2" 1)
desVar("pvtn3" 1)
desVar("pvtn4" 1)
desVar("pvtn5" 1)
desVar("pvtn6" 1)
desVar("pvtn7" 0)
desVar("pvtn8" 0)
desVar("pvtn9" 0)
desVar("pvtn10" 0)
desVar("pvtn11" 0)
desVar("pvtn12" 0)
desVar("pvtn13" 0)
run()
selectResults('tran)
pup_val = average((clip((v("/vdd" ?result "tran") - v("/outn" ?result "tran")) 2e-07 2.5e-07) / clip(i("/xdrv_p/out" ?result "tran") 2e-07 2.5e-07)))
pdn_val = (average((clip(v("/outp" ?result "tran") 2e-07 2.5e-07) / clip(i("/xdrv_p/out" ?result "tran") 2e-07 2.5e-07))) * -1)
fprintf(out_file "GOOD_29,SF,SF Cross Option 1 (SS Res),ss_res_bip_dio_disres,0.93,59.0,299747820,123,125,%f,%f,50.23,49.827\n" pup_val pdn_val)
drain(out_file)
printf("Result GOOD_29 -> pup=%f, pdn=%f (Target: pup=50.23, pdn=49.827)\n" pup_val pdn_val)

; --- Sim 30/35: [GOOD_30] SF (SF Cross Option 1 (SS Res)), V=0.99V, T=125.0C, pvtp=123, pvtn=125 ---
printf("\n>>> Running Sim 30/35: GOOD_30 (SF, ss_res_bip_dio_disres) V=0.99V, T=125.0C <<<\n")
desVar("tem" 125.0)
desVar("vreg" 0.99)
temp(125.0)
desVar("pvt0" 1)
desVar("pvt1" 1)
desVar("pvt2" 0)
desVar("pvt3" 1)
desVar("pvt4" 1)
desVar("pvt5" 1)
desVar("pvt6" 1)
desVar("pvt7" 0)
desVar("pvt8" 0)
desVar("pvt9" 0)
desVar("pvt10" 0)
desVar("pvt11" 0)
desVar("pvt12" 0)
desVar("pvt13" 0)
desVar("pvtn0" 1)
desVar("pvtn1" 0)
desVar("pvtn2" 1)
desVar("pvtn3" 1)
desVar("pvtn4" 1)
desVar("pvtn5" 1)
desVar("pvtn6" 1)
desVar("pvtn7" 0)
desVar("pvtn8" 0)
desVar("pvtn9" 0)
desVar("pvtn10" 0)
desVar("pvtn11" 0)
desVar("pvtn12" 0)
desVar("pvtn13" 0)
run()
selectResults('tran)
pup_val = average((clip((v("/vdd" ?result "tran") - v("/outn" ?result "tran")) 2e-07 2.5e-07) / clip(i("/xdrv_p/out" ?result "tran") 2e-07 2.5e-07)))
pdn_val = (average((clip(v("/outp" ?result "tran") 2e-07 2.5e-07) / clip(i("/xdrv_p/out" ?result "tran") 2e-07 2.5e-07))) * -1)
fprintf(out_file "GOOD_30,SF,SF Cross Option 1 (SS Res),ss_res_bip_dio_disres,0.99,125.0,312833150,123,125,%f,%f,51.49,51.13\n" pup_val pdn_val)
drain(out_file)
printf("Result GOOD_30 -> pup=%f, pdn=%f (Target: pup=51.49, pdn=51.13)\n" pup_val pdn_val)

; --- Sim 31/35: [GOOD_31] SF (SF Cross Option 2 (FF Res)), V=0.81V, T=-40.0C, pvtp=62, pvtn=123 ---
modelFile(
    '("/data/cad/pdk_all/pdk_tsmc/pdk_tsmc_28/PDK/TSMC_new_iPDK/models/spectre/crn28hpcp_1d8_elk_v1d0_2p2_shrink0d9_embedded_usage.scs" "sfmacro_mos_moscap")
    '("/data/cad/pdk_all/pdk_tsmc/pdk_tsmc_28/PDK/TSMC_new_iPDK/models/spectre/crn28hpcp_1d8_elk_v1d0_2p2_shrink0d9_embedded_usage.scs" "ff_res_bip_dio_disres")
    '("/data/cad/pdk_all/pdk_tsmc/pdk_tsmc_28/PDK/TSMC_new_iPDK/models/spectre/crn28hpcp_1d8_elk_v1d0_2p2_shrink0d9_embedded_usage.scs" "pre_simu")
)
printf("\n>>> Running Sim 31/35: GOOD_31 (SF, ff_res_bip_dio_disres) V=0.81V, T=-40.0C <<<\n")
desVar("tem" -40.0)
desVar("vreg" 0.81)
temp(-40.0)
desVar("pvt0" 0)
desVar("pvt1" 1)
desVar("pvt2" 1)
desVar("pvt3" 1)
desVar("pvt4" 1)
desVar("pvt5" 1)
desVar("pvt6" 0)
desVar("pvt7" 0)
desVar("pvt8" 0)
desVar("pvt9" 0)
desVar("pvt10" 0)
desVar("pvt11" 0)
desVar("pvt12" 0)
desVar("pvt13" 0)
desVar("pvtn0" 1)
desVar("pvtn1" 1)
desVar("pvtn2" 0)
desVar("pvtn3" 1)
desVar("pvtn4" 1)
desVar("pvtn5" 1)
desVar("pvtn6" 1)
desVar("pvtn7" 0)
desVar("pvtn8" 0)
desVar("pvtn9" 0)
desVar("pvtn10" 0)
desVar("pvtn11" 0)
desVar("pvtn12" 0)
desVar("pvtn13" 0)
run()
selectResults('tran)
pup_val = average((clip((v("/vdd" ?result "tran") - v("/outn" ?result "tran")) 2e-07 2.5e-07) / clip(i("/xdrv_p/out" ?result "tran") 2e-07 2.5e-07)))
pdn_val = (average((clip(v("/outp" ?result "tran") 2e-07 2.5e-07) / clip(i("/xdrv_p/out" ?result "tran") 2e-07 2.5e-07))) * -1)
fprintf(out_file "GOOD_31,SF,SF Cross Option 2 (FF Res),ff_res_bip_dio_disres,0.81,-40.0,241869650,62,123,%f,%f,50.113,49.848\n" pup_val pdn_val)
drain(out_file)
printf("Result GOOD_31 -> pup=%f, pdn=%f (Target: pup=50.113, pdn=49.848)\n" pup_val pdn_val)

; --- Sim 32/35: [GOOD_32] SF (SF Cross Option 2 (FF Res)), V=0.97V, T=-7.5C, pvtp=122, pvtn=123 ---
printf("\n>>> Running Sim 32/35: GOOD_32 (SF, ff_res_bip_dio_disres) V=0.97V, T=-7.5C <<<\n")
desVar("tem" -7.5)
desVar("vreg" 0.97)
temp(-7.5)
desVar("pvt0" 0)
desVar("pvt1" 1)
desVar("pvt2" 0)
desVar("pvt3" 1)
desVar("pvt4" 1)
desVar("pvt5" 1)
desVar("pvt6" 1)
desVar("pvt7" 0)
desVar("pvt8" 0)
desVar("pvt9" 0)
desVar("pvt10" 0)
desVar("pvt11" 0)
desVar("pvt12" 0)
desVar("pvt13" 0)
desVar("pvtn0" 1)
desVar("pvtn1" 1)
desVar("pvtn2" 0)
desVar("pvtn3" 1)
desVar("pvtn4" 1)
desVar("pvtn5" 1)
desVar("pvtn6" 1)
desVar("pvtn7" 0)
desVar("pvtn8" 0)
desVar("pvtn9" 0)
desVar("pvtn10" 0)
desVar("pvtn11" 0)
desVar("pvtn12" 0)
desVar("pvtn13" 0)
run()
selectResults('tran)
pup_val = average((clip((v("/vdd" ?result "tran") - v("/outn" ?result "tran")) 2e-07 2.5e-07) / clip(i("/xdrv_p/out" ?result "tran") 2e-07 2.5e-07)))
pdn_val = (average((clip(v("/outp" ?result "tran") 2e-07 2.5e-07) / clip(i("/xdrv_p/out" ?result "tran") 2e-07 2.5e-07))) * -1)
fprintf(out_file "GOOD_32,SF,SF Cross Option 2 (FF Res),ff_res_bip_dio_disres,0.97,-7.5,345124630,122,123,%f,%f,49.6,49.95\n" pup_val pdn_val)
drain(out_file)
printf("Result GOOD_32 -> pup=%f, pdn=%f (Target: pup=49.6, pdn=49.95)\n" pup_val pdn_val)

; --- Sim 33/35: [GOOD_33] SF (SF Cross Option 2 (FF Res)), V=0.81V, T=26.0C, pvtp=124, pvtn=125 ---
printf("\n>>> Running Sim 33/35: GOOD_33 (SF, ff_res_bip_dio_disres) V=0.81V, T=26.0C <<<\n")
desVar("tem" 26.0)
desVar("vreg" 0.81)
temp(26.0)
desVar("pvt0" 0)
desVar("pvt1" 0)
desVar("pvt2" 1)
desVar("pvt3" 1)
desVar("pvt4" 1)
desVar("pvt5" 1)
desVar("pvt6" 1)
desVar("pvt7" 0)
desVar("pvt8" 0)
desVar("pvt9" 0)
desVar("pvt10" 0)
desVar("pvt11" 0)
desVar("pvt12" 0)
desVar("pvt13" 0)
desVar("pvtn0" 1)
desVar("pvtn1" 0)
desVar("pvtn2" 1)
desVar("pvtn3" 1)
desVar("pvtn4" 1)
desVar("pvtn5" 1)
desVar("pvtn6" 1)
desVar("pvtn7" 0)
desVar("pvtn8" 0)
desVar("pvtn9" 0)
desVar("pvtn10" 0)
desVar("pvtn11" 0)
desVar("pvtn12" 0)
desVar("pvtn13" 0)
run()
selectResults('tran)
pup_val = average((clip((v("/vdd" ?result "tran") - v("/outn" ?result "tran")) 2e-07 2.5e-07) / clip(i("/xdrv_p/out" ?result "tran") 2e-07 2.5e-07)))
pdn_val = (average((clip(v("/outp" ?result "tran") 2e-07 2.5e-07) / clip(i("/xdrv_p/out" ?result "tran") 2e-07 2.5e-07))) * -1)
fprintf(out_file "GOOD_33,SF,SF Cross Option 2 (FF Res),ff_res_bip_dio_disres,0.81,26.0,233790580,124,125,%f,%f,50.54,50.425\n" pup_val pdn_val)
drain(out_file)
printf("Result GOOD_33 -> pup=%f, pdn=%f (Target: pup=50.54, pdn=50.425)\n" pup_val pdn_val)

; --- Sim 34/35: [GOOD_34] SF (SF Cross Option 2 (FF Res)), V=0.93V, T=59.0C, pvtp=123, pvtn=125 ---
printf("\n>>> Running Sim 34/35: GOOD_34 (SF, ff_res_bip_dio_disres) V=0.93V, T=59.0C <<<\n")
desVar("tem" 59.0)
desVar("vreg" 0.93)
temp(59.0)
desVar("pvt0" 1)
desVar("pvt1" 1)
desVar("pvt2" 0)
desVar("pvt3" 1)
desVar("pvt4" 1)
desVar("pvt5" 1)
desVar("pvt6" 1)
desVar("pvt7" 0)
desVar("pvt8" 0)
desVar("pvt9" 0)
desVar("pvt10" 0)
desVar("pvt11" 0)
desVar("pvt12" 0)
desVar("pvt13" 0)
desVar("pvtn0" 1)
desVar("pvtn1" 0)
desVar("pvtn2" 1)
desVar("pvtn3" 1)
desVar("pvtn4" 1)
desVar("pvtn5" 1)
desVar("pvtn6" 1)
desVar("pvtn7" 0)
desVar("pvtn8" 0)
desVar("pvtn9" 0)
desVar("pvtn10" 0)
desVar("pvtn11" 0)
desVar("pvtn12" 0)
desVar("pvtn13" 0)
run()
selectResults('tran)
pup_val = average((clip((v("/vdd" ?result "tran") - v("/outn" ?result "tran")) 2e-07 2.5e-07) / clip(i("/xdrv_p/out" ?result "tran") 2e-07 2.5e-07)))
pdn_val = (average((clip(v("/outp" ?result "tran") 2e-07 2.5e-07) / clip(i("/xdrv_p/out" ?result "tran") 2e-07 2.5e-07))) * -1)
fprintf(out_file "GOOD_34,SF,SF Cross Option 2 (FF Res),ff_res_bip_dio_disres,0.93,59.0,299747820,123,125,%f,%f,50.23,49.827\n" pup_val pdn_val)
drain(out_file)
printf("Result GOOD_34 -> pup=%f, pdn=%f (Target: pup=50.23, pdn=49.827)\n" pup_val pdn_val)

; --- Sim 35/35: [GOOD_35] SF (SF Cross Option 2 (FF Res)), V=0.99V, T=125.0C, pvtp=123, pvtn=125 ---
printf("\n>>> Running Sim 35/35: GOOD_35 (SF, ff_res_bip_dio_disres) V=0.99V, T=125.0C <<<\n")
desVar("tem" 125.0)
desVar("vreg" 0.99)
temp(125.0)
desVar("pvt0" 1)
desVar("pvt1" 1)
desVar("pvt2" 0)
desVar("pvt3" 1)
desVar("pvt4" 1)
desVar("pvt5" 1)
desVar("pvt6" 1)
desVar("pvt7" 0)
desVar("pvt8" 0)
desVar("pvt9" 0)
desVar("pvt10" 0)
desVar("pvt11" 0)
desVar("pvt12" 0)
desVar("pvt13" 0)
desVar("pvtn0" 1)
desVar("pvtn1" 0)
desVar("pvtn2" 1)
desVar("pvtn3" 1)
desVar("pvtn4" 1)
desVar("pvtn5" 1)
desVar("pvtn6" 1)
desVar("pvtn7" 0)
desVar("pvtn8" 0)
desVar("pvtn9" 0)
desVar("pvtn10" 0)
desVar("pvtn11" 0)
desVar("pvtn12" 0)
desVar("pvtn13" 0)
run()
selectResults('tran)
pup_val = average((clip((v("/vdd" ?result "tran") - v("/outn" ?result "tran")) 2e-07 2.5e-07) / clip(i("/xdrv_p/out" ?result "tran") 2e-07 2.5e-07)))
pdn_val = (average((clip(v("/outp" ?result "tran") 2e-07 2.5e-07) / clip(i("/xdrv_p/out" ?result "tran") 2e-07 2.5e-07))) * -1)
fprintf(out_file "GOOD_35,SF,SF Cross Option 2 (FF Res),ff_res_bip_dio_disres,0.99,125.0,312833150,123,125,%f,%f,51.49,51.13\n" pup_val pdn_val)
drain(out_file)
printf("Result GOOD_35 -> pup=%f, pdn=%f (Target: pup=51.49, pdn=51.13)\n" pup_val pdn_val)

close(out_file)
printf("\n=== ALL 35 SIMULATIONS COMPLETED! Results saved to results_all_35_good.csv ===\n")
exit()
