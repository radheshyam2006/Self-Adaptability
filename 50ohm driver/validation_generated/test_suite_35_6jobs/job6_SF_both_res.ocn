; =============================================================================
; CADENCE SPECTRE OCEAN SCRIPT: JOB 6 - SF_BOTH_RES
; Total Test Cases: 10 | PDK Model: 1.8V (crn28hpcp_1d8_elk...)
; Results CSV: results_job6_SF_both_res.csv | Results Directory: ./ocean_results_job6
; =============================================================================
simulator('spectre)
design("tsmc28_tx_tb" "tx_drv_ML" "schematic_seriliazer_top")
resultsDir("./ocean_results_job6")

analysis('dc ?saveOppoint t)
analysis('tran ?stop "275n")

envOption('termDirectionMismatch "ignore" 'termMismatch "ignore")
saveOption( ?infoOptions list(list("modelParameter" "models" "rawfile" "" "" "" t) list("element" "inst" "rawfile" "" "" "" t) list("outputParameter" "output" "rawfile" "" "" "" t) list("designParamVals" "parameters" "rawfile" "" "" "" t) list("primitives" "primitives" "rawfile" "" "" "" t) list("subckts" "subckts" "rawfile" "" "" "" t) list("asserts" "assert" "rawfile" "" "" "" nil) list("extremeinfo" "all" "logfile" "" "yes" "" nil) list("allcap" "allcap" "file" "" "" "" nil) list("<Click_To_Add>" "none" "rawfile" "" "" "" nil) ) )
save('i "/xdrv_p/out")

out_file = outfile("results_job6_SF_both_res.csv")
fprintf(out_file "test_id,corner,res_type,res_sec,vreg,temp,pmon,pvtp,pvtn,sim_pup,sim_pdn,excel_pup,excel_pdn\n")
drain(out_file)

; --- Sim 1/10: [GOOD_26] SF (SF Cross Option 1 (SS Res)), V=0.81V, T=-40.0C, pvtp=62, pvtn=123 ---
modelFile(
    '("/data/cad/pdk_all/pdk_tsmc/pdk_tsmc_28/PDK/TSMC_new_iPDK/models/spectre/crn28hpcp_1d8_elk_v1d0_2p2_shrink0d9_embedded_usage.scs" "sfmacro_mos_moscap")
    '("/data/cad/pdk_all/pdk_tsmc/pdk_tsmc_28/PDK/TSMC_new_iPDK/models/spectre/crn28hpcp_1d8_elk_v1d0_2p2_shrink0d9_embedded_usage.scs" "ss_res_bip_dio_disres")
    '("/data/cad/pdk_all/pdk_tsmc/pdk_tsmc_28/PDK/TSMC_new_iPDK/models/spectre/crn28hpcp_1d8_elk_v1d0_2p2_shrink0d9_embedded_usage.scs" "pre_simu")
)
printf("\n>>> [JOB 6: SF_both_res] Running Sim 1/10: GOOD_26 (SF, ss_res_bip_dio_disres) V=0.81V, T=-40.0C <<<\n")
desVar("tem" -40.0)
desVar("vreg" 0.81)
temp(-40.0)
desVar("pvt0" 0)
desVar("pvt1" 1)
desVar("pvt2" 1)
desVar("pvt3" 1)
desVar("pvt4" 1)
desVar("pvt5" 1)
desVar("pvt6" 0)
desVar("pvt7" 0)
desVar("pvt8" 0)
desVar("pvt9" 0)
desVar("pvt10" 0)
desVar("pvt11" 0)
desVar("pvt12" 0)
desVar("pvt13" 0)
desVar("pvtn0" 1)
desVar("pvtn1" 1)
desVar("pvtn2" 0)
desVar("pvtn3" 1)
desVar("pvtn4" 1)
desVar("pvtn5" 1)
desVar("pvtn6" 1)
desVar("pvtn7" 0)
desVar("pvtn8" 0)
desVar("pvtn9" 0)
desVar("pvtn10" 0)
desVar("pvtn11" 0)
desVar("pvtn12" 0)
desVar("pvtn13" 0)
run()
selectResults('tran)
pup_val = average((clip((v("/vdd" ?result "tran") - v("/outn" ?result "tran")) 2e-07 2.5e-07) / clip(i("/xdrv_p/out" ?result "tran") 2e-07 2.5e-07)))
pdn_val = (average((clip(v("/outp" ?result "tran") 2e-07 2.5e-07) / clip(i("/xdrv_p/out" ?result "tran") 2e-07 2.5e-07))) * -1)
fprintf(out_file "GOOD_26,SF,SF Cross Option 1 (SS Res),ss_res_bip_dio_disres,0.81,-40.0,241869650,62,123,%f,%f,50.113,49.848\n" pup_val pdn_val)
drain(out_file)
printf("Result GOOD_26 -> pup=%f, pdn=%f (Target: pup=50.113, pdn=49.848)\n" pup_val pdn_val)

; --- Sim 2/10: [GOOD_27] SF (SF Cross Option 1 (SS Res)), V=0.97V, T=-7.5C, pvtp=122, pvtn=123 ---
printf("\n>>> [JOB 6: SF_both_res] Running Sim 2/10: GOOD_27 (SF, ss_res_bip_dio_disres) V=0.97V, T=-7.5C <<<\n")
desVar("tem" -7.5)
desVar("vreg" 0.97)
temp(-7.5)
desVar("pvt0" 0)
desVar("pvt1" 1)
desVar("pvt2" 0)
desVar("pvt3" 1)
desVar("pvt4" 1)
desVar("pvt5" 1)
desVar("pvt6" 1)
desVar("pvt7" 0)
desVar("pvt8" 0)
desVar("pvt9" 0)
desVar("pvt10" 0)
desVar("pvt11" 0)
desVar("pvt12" 0)
desVar("pvt13" 0)
desVar("pvtn0" 1)
desVar("pvtn1" 1)
desVar("pvtn2" 0)
desVar("pvtn3" 1)
desVar("pvtn4" 1)
desVar("pvtn5" 1)
desVar("pvtn6" 1)
desVar("pvtn7" 0)
desVar("pvtn8" 0)
desVar("pvtn9" 0)
desVar("pvtn10" 0)
desVar("pvtn11" 0)
desVar("pvtn12" 0)
desVar("pvtn13" 0)
run()
selectResults('tran)
pup_val = average((clip((v("/vdd" ?result "tran") - v("/outn" ?result "tran")) 2e-07 2.5e-07) / clip(i("/xdrv_p/out" ?result "tran") 2e-07 2.5e-07)))
pdn_val = (average((clip(v("/outp" ?result "tran") 2e-07 2.5e-07) / clip(i("/xdrv_p/out" ?result "tran") 2e-07 2.5e-07))) * -1)
fprintf(out_file "GOOD_27,SF,SF Cross Option 1 (SS Res),ss_res_bip_dio_disres,0.97,-7.5,345124630,122,123,%f,%f,49.6,49.95\n" pup_val pdn_val)
drain(out_file)
printf("Result GOOD_27 -> pup=%f, pdn=%f (Target: pup=49.6, pdn=49.95)\n" pup_val pdn_val)

; --- Sim 3/10: [GOOD_28] SF (SF Cross Option 1 (SS Res)), V=0.81V, T=26.0C, pvtp=124, pvtn=125 ---
printf("\n>>> [JOB 6: SF_both_res] Running Sim 3/10: GOOD_28 (SF, ss_res_bip_dio_disres) V=0.81V, T=26.0C <<<\n")
desVar("tem" 26.0)
desVar("vreg" 0.81)
temp(26.0)
desVar("pvt0" 0)
desVar("pvt1" 0)
desVar("pvt2" 1)
desVar("pvt3" 1)
desVar("pvt4" 1)
desVar("pvt5" 1)
desVar("pvt6" 1)
desVar("pvt7" 0)
desVar("pvt8" 0)
desVar("pvt9" 0)
desVar("pvt10" 0)
desVar("pvt11" 0)
desVar("pvt12" 0)
desVar("pvt13" 0)
desVar("pvtn0" 1)
desVar("pvtn1" 0)
desVar("pvtn2" 1)
desVar("pvtn3" 1)
desVar("pvtn4" 1)
desVar("pvtn5" 1)
desVar("pvtn6" 1)
desVar("pvtn7" 0)
desVar("pvtn8" 0)
desVar("pvtn9" 0)
desVar("pvtn10" 0)
desVar("pvtn11" 0)
desVar("pvtn12" 0)
desVar("pvtn13" 0)
run()
selectResults('tran)
pup_val = average((clip((v("/vdd" ?result "tran") - v("/outn" ?result "tran")) 2e-07 2.5e-07) / clip(i("/xdrv_p/out" ?result "tran") 2e-07 2.5e-07)))
pdn_val = (average((clip(v("/outp" ?result "tran") 2e-07 2.5e-07) / clip(i("/xdrv_p/out" ?result "tran") 2e-07 2.5e-07))) * -1)
fprintf(out_file "GOOD_28,SF,SF Cross Option 1 (SS Res),ss_res_bip_dio_disres,0.81,26.0,233790580,124,125,%f,%f,50.54,50.425\n" pup_val pdn_val)
drain(out_file)
printf("Result GOOD_28 -> pup=%f, pdn=%f (Target: pup=50.54, pdn=50.425)\n" pup_val pdn_val)

; --- Sim 4/10: [GOOD_29] SF (SF Cross Option 1 (SS Res)), V=0.93V, T=59.0C, pvtp=123, pvtn=125 ---
printf("\n>>> [JOB 6: SF_both_res] Running Sim 4/10: GOOD_29 (SF, ss_res_bip_dio_disres) V=0.93V, T=59.0C <<<\n")
desVar("tem" 59.0)
desVar("vreg" 0.93)
temp(59.0)
desVar("pvt0" 1)
desVar("pvt1" 1)
desVar("pvt2" 0)
desVar("pvt3" 1)
desVar("pvt4" 1)
desVar("pvt5" 1)
desVar("pvt6" 1)
desVar("pvt7" 0)
desVar("pvt8" 0)
desVar("pvt9" 0)
desVar("pvt10" 0)
desVar("pvt11" 0)
desVar("pvt12" 0)
desVar("pvt13" 0)
desVar("pvtn0" 1)
desVar("pvtn1" 0)
desVar("pvtn2" 1)
desVar("pvtn3" 1)
desVar("pvtn4" 1)
desVar("pvtn5" 1)
desVar("pvtn6" 1)
desVar("pvtn7" 0)
desVar("pvtn8" 0)
desVar("pvtn9" 0)
desVar("pvtn10" 0)
desVar("pvtn11" 0)
desVar("pvtn12" 0)
desVar("pvtn13" 0)
run()
selectResults('tran)
pup_val = average((clip((v("/vdd" ?result "tran") - v("/outn" ?result "tran")) 2e-07 2.5e-07) / clip(i("/xdrv_p/out" ?result "tran") 2e-07 2.5e-07)))
pdn_val = (average((clip(v("/outp" ?result "tran") 2e-07 2.5e-07) / clip(i("/xdrv_p/out" ?result "tran") 2e-07 2.5e-07))) * -1)
fprintf(out_file "GOOD_29,SF,SF Cross Option 1 (SS Res),ss_res_bip_dio_disres,0.93,59.0,299747820,123,125,%f,%f,50.23,49.827\n" pup_val pdn_val)
drain(out_file)
printf("Result GOOD_29 -> pup=%f, pdn=%f (Target: pup=50.23, pdn=49.827)\n" pup_val pdn_val)

; --- Sim 5/10: [GOOD_30] SF (SF Cross Option 1 (SS Res)), V=0.99V, T=125.0C, pvtp=123, pvtn=125 ---
printf("\n>>> [JOB 6: SF_both_res] Running Sim 5/10: GOOD_30 (SF, ss_res_bip_dio_disres) V=0.99V, T=125.0C <<<\n")
desVar("tem" 125.0)
desVar("vreg" 0.99)
temp(125.0)
desVar("pvt0" 1)
desVar("pvt1" 1)
desVar("pvt2" 0)
desVar("pvt3" 1)
desVar("pvt4" 1)
desVar("pvt5" 1)
desVar("pvt6" 1)
desVar("pvt7" 0)
desVar("pvt8" 0)
desVar("pvt9" 0)
desVar("pvt10" 0)
desVar("pvt11" 0)
desVar("pvt12" 0)
desVar("pvt13" 0)
desVar("pvtn0" 1)
desVar("pvtn1" 0)
desVar("pvtn2" 1)
desVar("pvtn3" 1)
desVar("pvtn4" 1)
desVar("pvtn5" 1)
desVar("pvtn6" 1)
desVar("pvtn7" 0)
desVar("pvtn8" 0)
desVar("pvtn9" 0)
desVar("pvtn10" 0)
desVar("pvtn11" 0)
desVar("pvtn12" 0)
desVar("pvtn13" 0)
run()
selectResults('tran)
pup_val = average((clip((v("/vdd" ?result "tran") - v("/outn" ?result "tran")) 2e-07 2.5e-07) / clip(i("/xdrv_p/out" ?result "tran") 2e-07 2.5e-07)))
pdn_val = (average((clip(v("/outp" ?result "tran") 2e-07 2.5e-07) / clip(i("/xdrv_p/out" ?result "tran") 2e-07 2.5e-07))) * -1)
fprintf(out_file "GOOD_30,SF,SF Cross Option 1 (SS Res),ss_res_bip_dio_disres,0.99,125.0,312833150,123,125,%f,%f,51.49,51.13\n" pup_val pdn_val)
drain(out_file)
printf("Result GOOD_30 -> pup=%f, pdn=%f (Target: pup=51.49, pdn=51.13)\n" pup_val pdn_val)

; --- Sim 6/10: [GOOD_31] SF (SF Cross Option 2 (FF Res)), V=0.81V, T=-40.0C, pvtp=62, pvtn=123 ---
modelFile(
    '("/data/cad/pdk_all/pdk_tsmc/pdk_tsmc_28/PDK/TSMC_new_iPDK/models/spectre/crn28hpcp_1d8_elk_v1d0_2p2_shrink0d9_embedded_usage.scs" "sfmacro_mos_moscap")
    '("/data/cad/pdk_all/pdk_tsmc/pdk_tsmc_28/PDK/TSMC_new_iPDK/models/spectre/crn28hpcp_1d8_elk_v1d0_2p2_shrink0d9_embedded_usage.scs" "ff_res_bip_dio_disres")
    '("/data/cad/pdk_all/pdk_tsmc/pdk_tsmc_28/PDK/TSMC_new_iPDK/models/spectre/crn28hpcp_1d8_elk_v1d0_2p2_shrink0d9_embedded_usage.scs" "pre_simu")
)
printf("\n>>> [JOB 6: SF_both_res] Running Sim 6/10: GOOD_31 (SF, ff_res_bip_dio_disres) V=0.81V, T=-40.0C <<<\n")
desVar("tem" -40.0)
desVar("vreg" 0.81)
temp(-40.0)
desVar("pvt0" 0)
desVar("pvt1" 1)
desVar("pvt2" 1)
desVar("pvt3" 1)
desVar("pvt4" 1)
desVar("pvt5" 1)
desVar("pvt6" 0)
desVar("pvt7" 0)
desVar("pvt8" 0)
desVar("pvt9" 0)
desVar("pvt10" 0)
desVar("pvt11" 0)
desVar("pvt12" 0)
desVar("pvt13" 0)
desVar("pvtn0" 1)
desVar("pvtn1" 1)
desVar("pvtn2" 0)
desVar("pvtn3" 1)
desVar("pvtn4" 1)
desVar("pvtn5" 1)
desVar("pvtn6" 1)
desVar("pvtn7" 0)
desVar("pvtn8" 0)
desVar("pvtn9" 0)
desVar("pvtn10" 0)
desVar("pvtn11" 0)
desVar("pvtn12" 0)
desVar("pvtn13" 0)
run()
selectResults('tran)
pup_val = average((clip((v("/vdd" ?result "tran") - v("/outn" ?result "tran")) 2e-07 2.5e-07) / clip(i("/xdrv_p/out" ?result "tran") 2e-07 2.5e-07)))
pdn_val = (average((clip(v("/outp" ?result "tran") 2e-07 2.5e-07) / clip(i("/xdrv_p/out" ?result "tran") 2e-07 2.5e-07))) * -1)
fprintf(out_file "GOOD_31,SF,SF Cross Option 2 (FF Res),ff_res_bip_dio_disres,0.81,-40.0,241869650,62,123,%f,%f,50.113,49.848\n" pup_val pdn_val)
drain(out_file)
printf("Result GOOD_31 -> pup=%f, pdn=%f (Target: pup=50.113, pdn=49.848)\n" pup_val pdn_val)

; --- Sim 7/10: [GOOD_32] SF (SF Cross Option 2 (FF Res)), V=0.97V, T=-7.5C, pvtp=122, pvtn=123 ---
printf("\n>>> [JOB 6: SF_both_res] Running Sim 7/10: GOOD_32 (SF, ff_res_bip_dio_disres) V=0.97V, T=-7.5C <<<\n")
desVar("tem" -7.5)
desVar("vreg" 0.97)
temp(-7.5)
desVar("pvt0" 0)
desVar("pvt1" 1)
desVar("pvt2" 0)
desVar("pvt3" 1)
desVar("pvt4" 1)
desVar("pvt5" 1)
desVar("pvt6" 1)
desVar("pvt7" 0)
desVar("pvt8" 0)
desVar("pvt9" 0)
desVar("pvt10" 0)
desVar("pvt11" 0)
desVar("pvt12" 0)
desVar("pvt13" 0)
desVar("pvtn0" 1)
desVar("pvtn1" 1)
desVar("pvtn2" 0)
desVar("pvtn3" 1)
desVar("pvtn4" 1)
desVar("pvtn5" 1)
desVar("pvtn6" 1)
desVar("pvtn7" 0)
desVar("pvtn8" 0)
desVar("pvtn9" 0)
desVar("pvtn10" 0)
desVar("pvtn11" 0)
desVar("pvtn12" 0)
desVar("pvtn13" 0)
run()
selectResults('tran)
pup_val = average((clip((v("/vdd" ?result "tran") - v("/outn" ?result "tran")) 2e-07 2.5e-07) / clip(i("/xdrv_p/out" ?result "tran") 2e-07 2.5e-07)))
pdn_val = (average((clip(v("/outp" ?result "tran") 2e-07 2.5e-07) / clip(i("/xdrv_p/out" ?result "tran") 2e-07 2.5e-07))) * -1)
fprintf(out_file "GOOD_32,SF,SF Cross Option 2 (FF Res),ff_res_bip_dio_disres,0.97,-7.5,345124630,122,123,%f,%f,49.6,49.95\n" pup_val pdn_val)
drain(out_file)
printf("Result GOOD_32 -> pup=%f, pdn=%f (Target: pup=49.6, pdn=49.95)\n" pup_val pdn_val)

; --- Sim 8/10: [GOOD_33] SF (SF Cross Option 2 (FF Res)), V=0.81V, T=26.0C, pvtp=124, pvtn=125 ---
printf("\n>>> [JOB 6: SF_both_res] Running Sim 8/10: GOOD_33 (SF, ff_res_bip_dio_disres) V=0.81V, T=26.0C <<<\n")
desVar("tem" 26.0)
desVar("vreg" 0.81)
temp(26.0)
desVar("pvt0" 0)
desVar("pvt1" 0)
desVar("pvt2" 1)
desVar("pvt3" 1)
desVar("pvt4" 1)
desVar("pvt5" 1)
desVar("pvt6" 1)
desVar("pvt7" 0)
desVar("pvt8" 0)
desVar("pvt9" 0)
desVar("pvt10" 0)
desVar("pvt11" 0)
desVar("pvt12" 0)
desVar("pvt13" 0)
desVar("pvtn0" 1)
desVar("pvtn1" 0)
desVar("pvtn2" 1)
desVar("pvtn3" 1)
desVar("pvtn4" 1)
desVar("pvtn5" 1)
desVar("pvtn6" 1)
desVar("pvtn7" 0)
desVar("pvtn8" 0)
desVar("pvtn9" 0)
desVar("pvtn10" 0)
desVar("pvtn11" 0)
desVar("pvtn12" 0)
desVar("pvtn13" 0)
run()
selectResults('tran)
pup_val = average((clip((v("/vdd" ?result "tran") - v("/outn" ?result "tran")) 2e-07 2.5e-07) / clip(i("/xdrv_p/out" ?result "tran") 2e-07 2.5e-07)))
pdn_val = (average((clip(v("/outp" ?result "tran") 2e-07 2.5e-07) / clip(i("/xdrv_p/out" ?result "tran") 2e-07 2.5e-07))) * -1)
fprintf(out_file "GOOD_33,SF,SF Cross Option 2 (FF Res),ff_res_bip_dio_disres,0.81,26.0,233790580,124,125,%f,%f,50.54,50.425\n" pup_val pdn_val)
drain(out_file)
printf("Result GOOD_33 -> pup=%f, pdn=%f (Target: pup=50.54, pdn=50.425)\n" pup_val pdn_val)

; --- Sim 9/10: [GOOD_34] SF (SF Cross Option 2 (FF Res)), V=0.93V, T=59.0C, pvtp=123, pvtn=125 ---
printf("\n>>> [JOB 6: SF_both_res] Running Sim 9/10: GOOD_34 (SF, ff_res_bip_dio_disres) V=0.93V, T=59.0C <<<\n")
desVar("tem" 59.0)
desVar("vreg" 0.93)
temp(59.0)
desVar("pvt0" 1)
desVar("pvt1" 1)
desVar("pvt2" 0)
desVar("pvt3" 1)
desVar("pvt4" 1)
desVar("pvt5" 1)
desVar("pvt6" 1)
desVar("pvt7" 0)
desVar("pvt8" 0)
desVar("pvt9" 0)
desVar("pvt10" 0)
desVar("pvt11" 0)
desVar("pvt12" 0)
desVar("pvt13" 0)
desVar("pvtn0" 1)
desVar("pvtn1" 0)
desVar("pvtn2" 1)
desVar("pvtn3" 1)
desVar("pvtn4" 1)
desVar("pvtn5" 1)
desVar("pvtn6" 1)
desVar("pvtn7" 0)
desVar("pvtn8" 0)
desVar("pvtn9" 0)
desVar("pvtn10" 0)
desVar("pvtn11" 0)
desVar("pvtn12" 0)
desVar("pvtn13" 0)
run()
selectResults('tran)
pup_val = average((clip((v("/vdd" ?result "tran") - v("/outn" ?result "tran")) 2e-07 2.5e-07) / clip(i("/xdrv_p/out" ?result "tran") 2e-07 2.5e-07)))
pdn_val = (average((clip(v("/outp" ?result "tran") 2e-07 2.5e-07) / clip(i("/xdrv_p/out" ?result "tran") 2e-07 2.5e-07))) * -1)
fprintf(out_file "GOOD_34,SF,SF Cross Option 2 (FF Res),ff_res_bip_dio_disres,0.93,59.0,299747820,123,125,%f,%f,50.23,49.827\n" pup_val pdn_val)
drain(out_file)
printf("Result GOOD_34 -> pup=%f, pdn=%f (Target: pup=50.23, pdn=49.827)\n" pup_val pdn_val)

; --- Sim 10/10: [GOOD_35] SF (SF Cross Option 2 (FF Res)), V=0.99V, T=125.0C, pvtp=123, pvtn=125 ---
printf("\n>>> [JOB 6: SF_both_res] Running Sim 10/10: GOOD_35 (SF, ff_res_bip_dio_disres) V=0.99V, T=125.0C <<<\n")
desVar("tem" 125.0)
desVar("vreg" 0.99)
temp(125.0)
desVar("pvt0" 1)
desVar("pvt1" 1)
desVar("pvt2" 0)
desVar("pvt3" 1)
desVar("pvt4" 1)
desVar("pvt5" 1)
desVar("pvt6" 1)
desVar("pvt7" 0)
desVar("pvt8" 0)
desVar("pvt9" 0)
desVar("pvt10" 0)
desVar("pvt11" 0)
desVar("pvt12" 0)
desVar("pvt13" 0)
desVar("pvtn0" 1)
desVar("pvtn1" 0)
desVar("pvtn2" 1)
desVar("pvtn3" 1)
desVar("pvtn4" 1)
desVar("pvtn5" 1)
desVar("pvtn6" 1)
desVar("pvtn7" 0)
desVar("pvtn8" 0)
desVar("pvtn9" 0)
desVar("pvtn10" 0)
desVar("pvtn11" 0)
desVar("pvtn12" 0)
desVar("pvtn13" 0)
run()
selectResults('tran)
pup_val = average((clip((v("/vdd" ?result "tran") - v("/outn" ?result "tran")) 2e-07 2.5e-07) / clip(i("/xdrv_p/out" ?result "tran") 2e-07 2.5e-07)))
pdn_val = (average((clip(v("/outp" ?result "tran") 2e-07 2.5e-07) / clip(i("/xdrv_p/out" ?result "tran") 2e-07 2.5e-07))) * -1)
fprintf(out_file "GOOD_35,SF,SF Cross Option 2 (FF Res),ff_res_bip_dio_disres,0.99,125.0,312833150,123,125,%f,%f,51.49,51.13\n" pup_val pdn_val)
drain(out_file)
printf("Result GOOD_35 -> pup=%f, pdn=%f (Target: pup=51.49, pdn=51.13)\n" pup_val pdn_val)

close(out_file)
printf("\n=== JOB 6 (SF_both_res) COMPLETED! Results saved to results_job6_SF_both_res.csv ===\n")
exit()
