; =============================================================================
; CADENCE SPECTRE OCEAN SCRIPT: JOB 5 - FS_SSRES
; Total Test Cases: 5 | PDK Model: 1.8V (crn28hpcp_1d8_elk...)
; Results CSV: results_job5_FS_ssres.csv | Results Directory: ./ocean_results_job5
; =============================================================================
simulator('spectre)
design("tsmc28_tx_tb" "tx_drv_ML" "schematic_seriliazer_top")
resultsDir("./ocean_results_job5")

; modelFile declared once at top
modelFile(
    '("/data/cad/pdk_all/pdk_tsmc/pdk_tsmc_28/PDK/TSMC_new_iPDK/models/spectre/crn28hpcp_1d8_elk_v1d0_2p2_shrink0d9_embedded_usage.scs" "fsmacro_mos_moscap")
    '("/data/cad/pdk_all/pdk_tsmc/pdk_tsmc_28/PDK/TSMC_new_iPDK/models/spectre/crn28hpcp_1d8_elk_v1d0_2p2_shrink0d9_embedded_usage.scs" "ss_res_bip_dio_disres")
    '("/data/cad/pdk_all/pdk_tsmc/pdk_tsmc_28/PDK/TSMC_new_iPDK/models/spectre/crn28hpcp_1d8_elk_v1d0_2p2_shrink0d9_embedded_usage.scs" "pre_simu")
)

analysis('dc ?saveOppoint t)
analysis('tran ?stop "275n")

envOption('termDirectionMismatch "ignore" 'termMismatch "ignore")
saveOption( ?infoOptions list(list("modelParameter" "models" "rawfile" "" "" "" t) list("element" "inst" "rawfile" "" "" "" t) list("outputParameter" "output" "rawfile" "" "" "" t) list("designParamVals" "parameters" "rawfile" "" "" "" t) list("primitives" "primitives" "rawfile" "" "" "" t) list("subckts" "subckts" "rawfile" "" "" "" t) list("asserts" "assert" "rawfile" "" "" "" nil) list("extremeinfo" "all" "logfile" "" "yes" "" nil) list("allcap" "allcap" "file" "" "" "" nil) list("<Click_To_Add>" "none" "rawfile" "" "" "" nil) ) )
save('i "/xdrv_p/out")

out_file = outfile("results_job5_FS_ssres.csv")
fprintf(out_file "test_id,corner,res_type,res_sec,vreg,temp,pmon,pvtp,pvtn,sim_pup,sim_pdn,excel_pup,excel_pdn\n")
drain(out_file)

; --- Sim 1/5: [GOOD_21] FS (FS Cross Option 2 (SS Res)), V=0.81V, T=-40.0C, pvtp=28, pvtn=14 ---
printf("\n>>> [JOB 5: FS_ssres] Running Sim 1/5: GOOD_21 (FS, ss_res_bip_dio_disres) V=0.81V, T=-40.0C <<<\n")
desVar("tem" -40.0)
desVar("vreg" 0.81)
temp(-40.0)
desVar("pvt0" 0)
desVar("pvt1" 0)
desVar("pvt2" 1)
desVar("pvt3" 1)
desVar("pvt4" 1)
desVar("pvt5" 0)
desVar("pvt6" 0)
desVar("pvt7" 0)
desVar("pvt8" 0)
desVar("pvt9" 0)
desVar("pvt10" 0)
desVar("pvt11" 0)
desVar("pvt12" 0)
desVar("pvt13" 0)
desVar("pvtn0" 0)
desVar("pvtn1" 1)
desVar("pvtn2" 1)
desVar("pvtn3" 1)
desVar("pvtn4" 0)
desVar("pvtn5" 0)
desVar("pvtn6" 0)
desVar("pvtn7" 0)
desVar("pvtn8" 0)
desVar("pvtn9" 0)
desVar("pvtn10" 0)
desVar("pvtn11" 0)
desVar("pvtn12" 0)
desVar("pvtn13" 0)
run()
selectResults('tran)
pup_val = average((clip((v("/vdd" ?result "tran") - v("/outn" ?result "tran")) 2e-07 2.5e-07) / clip(i("/xdrv_p/out" ?result "tran") 2e-07 2.5e-07)))
pdn_val = (average((clip(v("/outp" ?result "tran") 2e-07 2.5e-07) / clip(i("/xdrv_p/out" ?result "tran") 2e-07 2.5e-07))) * -1)
fprintf(out_file "GOOD_21,FS,FS Cross Option 2 (SS Res),ss_res_bip_dio_disres,0.81,-40.0,253705610,28,14,%f,%f,49.628,49.02\n" pup_val pdn_val)
drain(out_file)
printf("Result GOOD_21 -> pup=%f, pdn=%f (Target: pup=49.628, pdn=49.02)\n" pup_val pdn_val)

; --- Sim 2/5: [GOOD_22] FS (FS Cross Option 2 (SS Res)), V=0.81V, T=-11.5C, pvtp=28, pvtn=14 ---
printf("\n>>> [JOB 5: FS_ssres] Running Sim 2/5: GOOD_22 (FS, ss_res_bip_dio_disres) V=0.81V, T=-11.5C <<<\n")
desVar("tem" -11.5)
desVar("vreg" 0.81)
temp(-11.5)
desVar("pvt0" 0)
desVar("pvt1" 0)
desVar("pvt2" 1)
desVar("pvt3" 1)
desVar("pvt4" 1)
desVar("pvt5" 0)
desVar("pvt6" 0)
desVar("pvt7" 0)
desVar("pvt8" 0)
desVar("pvt9" 0)
desVar("pvt10" 0)
desVar("pvt11" 0)
desVar("pvt12" 0)
desVar("pvt13" 0)
desVar("pvtn0" 0)
desVar("pvtn1" 1)
desVar("pvtn2" 1)
desVar("pvtn3" 1)
desVar("pvtn4" 0)
desVar("pvtn5" 0)
desVar("pvtn6" 0)
desVar("pvtn7" 0)
desVar("pvtn8" 0)
desVar("pvtn9" 0)
desVar("pvtn10" 0)
desVar("pvtn11" 0)
desVar("pvtn12" 0)
desVar("pvtn13" 0)
run()
selectResults('tran)
pup_val = average((clip((v("/vdd" ?result "tran") - v("/outn" ?result "tran")) 2e-07 2.5e-07) / clip(i("/xdrv_p/out" ?result "tran") 2e-07 2.5e-07)))
pdn_val = (average((clip(v("/outp" ?result "tran") 2e-07 2.5e-07) / clip(i("/xdrv_p/out" ?result "tran") 2e-07 2.5e-07))) * -1)
fprintf(out_file "GOOD_22,FS,FS Cross Option 2 (SS Res),ss_res_bip_dio_disres,0.81,-11.5,250502300,28,14,%f,%f,50.504,49.73\n" pup_val pdn_val)
drain(out_file)
printf("Result GOOD_22 -> pup=%f, pdn=%f (Target: pup=50.504, pdn=49.73)\n" pup_val pdn_val)

; --- Sim 3/5: [GOOD_23] FS (FS Cross Option 2 (SS Res)), V=0.93V, T=25.0C, pvtp=28, pvtn=13 ---
printf("\n>>> [JOB 5: FS_ssres] Running Sim 3/5: GOOD_23 (FS, ss_res_bip_dio_disres) V=0.93V, T=25.0C <<<\n")
desVar("tem" 25.0)
desVar("vreg" 0.93)
temp(25.0)
desVar("pvt0" 0)
desVar("pvt1" 0)
desVar("pvt2" 1)
desVar("pvt3" 1)
desVar("pvt4" 1)
desVar("pvt5" 0)
desVar("pvt6" 0)
desVar("pvt7" 0)
desVar("pvt8" 0)
desVar("pvt9" 0)
desVar("pvt10" 0)
desVar("pvt11" 0)
desVar("pvt12" 0)
desVar("pvt13" 0)
desVar("pvtn0" 1)
desVar("pvtn1" 0)
desVar("pvtn2" 1)
desVar("pvtn3" 1)
desVar("pvtn4" 0)
desVar("pvtn5" 0)
desVar("pvtn6" 0)
desVar("pvtn7" 0)
desVar("pvtn8" 0)
desVar("pvtn9" 0)
desVar("pvtn10" 0)
desVar("pvtn11" 0)
desVar("pvtn12" 0)
desVar("pvtn13" 0)
run()
selectResults('tran)
pup_val = average((clip((v("/vdd" ?result "tran") - v("/outn" ?result "tran")) 2e-07 2.5e-07) / clip(i("/xdrv_p/out" ?result "tran") 2e-07 2.5e-07)))
pdn_val = (average((clip(v("/outp" ?result "tran") 2e-07 2.5e-07) / clip(i("/xdrv_p/out" ?result "tran") 2e-07 2.5e-07))) * -1)
fprintf(out_file "GOOD_23,FS,FS Cross Option 2 (SS Res),ss_res_bip_dio_disres,0.93,25.0,331170490,28,13,%f,%f,49.177,51.08\n" pup_val pdn_val)
drain(out_file)
printf("Result GOOD_23 -> pup=%f, pdn=%f (Target: pup=49.177, pdn=51.08)\n" pup_val pdn_val)

; --- Sim 4/5: [GOOD_24] FS (FS Cross Option 2 (SS Res)), V=0.95V, T=55.0C, pvtp=28, pvtn=14 ---
printf("\n>>> [JOB 5: FS_ssres] Running Sim 4/5: GOOD_24 (FS, ss_res_bip_dio_disres) V=0.95V, T=55.0C <<<\n")
desVar("tem" 55.0)
desVar("vreg" 0.95)
temp(55.0)
desVar("pvt0" 0)
desVar("pvt1" 0)
desVar("pvt2" 1)
desVar("pvt3" 1)
desVar("pvt4" 1)
desVar("pvt5" 0)
desVar("pvt6" 0)
desVar("pvt7" 0)
desVar("pvt8" 0)
desVar("pvt9" 0)
desVar("pvt10" 0)
desVar("pvt11" 0)
desVar("pvt12" 0)
desVar("pvt13" 0)
desVar("pvtn0" 0)
desVar("pvtn1" 1)
desVar("pvtn2" 1)
desVar("pvtn3" 1)
desVar("pvtn4" 0)
desVar("pvtn5" 0)
desVar("pvtn6" 0)
desVar("pvtn7" 0)
desVar("pvtn8" 0)
desVar("pvtn9" 0)
desVar("pvtn10" 0)
desVar("pvtn11" 0)
desVar("pvtn12" 0)
desVar("pvtn13" 0)
run()
selectResults('tran)
pup_val = average((clip((v("/vdd" ?result "tran") - v("/outn" ?result "tran")) 2e-07 2.5e-07) / clip(i("/xdrv_p/out" ?result "tran") 2e-07 2.5e-07)))
pdn_val = (average((clip(v("/outp" ?result "tran") 2e-07 2.5e-07) / clip(i("/xdrv_p/out" ?result "tran") 2e-07 2.5e-07))) * -1)
fprintf(out_file "GOOD_24,FS,FS Cross Option 2 (SS Res),ss_res_bip_dio_disres,0.95,55.0,334869190,28,14,%f,%f,50.002,49.98\n" pup_val pdn_val)
drain(out_file)
printf("Result GOOD_24 -> pup=%f, pdn=%f (Target: pup=50.002, pdn=49.98)\n" pup_val pdn_val)

; --- Sim 5/5: [GOOD_25] FS (FS Cross Option 2 (SS Res)), V=0.99V, T=125.0C, pvtp=29, pvtn=14 ---
printf("\n>>> [JOB 5: FS_ssres] Running Sim 5/5: GOOD_25 (FS, ss_res_bip_dio_disres) V=0.99V, T=125.0C <<<\n")
desVar("tem" 125.0)
desVar("vreg" 0.99)
temp(125.0)
desVar("pvt0" 1)
desVar("pvt1" 0)
desVar("pvt2" 1)
desVar("pvt3" 1)
desVar("pvt4" 1)
desVar("pvt5" 0)
desVar("pvt6" 0)
desVar("pvt7" 0)
desVar("pvt8" 0)
desVar("pvt9" 0)
desVar("pvt10" 0)
desVar("pvt11" 0)
desVar("pvt12" 0)
desVar("pvt13" 0)
desVar("pvtn0" 0)
desVar("pvtn1" 1)
desVar("pvtn2" 1)
desVar("pvtn3" 1)
desVar("pvtn4" 0)
desVar("pvtn5" 0)
desVar("pvtn6" 0)
desVar("pvtn7" 0)
desVar("pvtn8" 0)
desVar("pvtn9" 0)
desVar("pvtn10" 0)
desVar("pvtn11" 0)
desVar("pvtn12" 0)
desVar("pvtn13" 0)
run()
selectResults('tran)
pup_val = average((clip((v("/vdd" ?result "tran") - v("/outn" ?result "tran")) 2e-07 2.5e-07) / clip(i("/xdrv_p/out" ?result "tran") 2e-07 2.5e-07)))
pdn_val = (average((clip(v("/outp" ?result "tran") 2e-07 2.5e-07) / clip(i("/xdrv_p/out" ?result "tran") 2e-07 2.5e-07))) * -1)
fprintf(out_file "GOOD_25,FS,FS Cross Option 2 (SS Res),ss_res_bip_dio_disres,0.99,125.0,338001700,29,14,%f,%f,51.628,50.99\n" pup_val pdn_val)
drain(out_file)
printf("Result GOOD_25 -> pup=%f, pdn=%f (Target: pup=51.628, pdn=50.99)\n" pup_val pdn_val)

close(out_file)
printf("\n=== JOB 5 (FS_ssres) COMPLETED! Results saved to results_job5_FS_ssres.csv ===\n")
exit()
