; -----------------------------------------------------------------------------
; Cadence Spectre OCEAN Script: BAD - SS
; PDK Model: TSMC 28nm 1.8V (crn28hpcp_1d8_elk...)
; MOS Section: ssmacro_mos_moscap | Resistor Section: ss_res_bip_dio_disres
; -----------------------------------------------------------------------------
simulator('spectre)
design("tsmc28_tx_tb" "tx_drv_ML" "schematic_seriliazer_top")
resultsDir("./ocean_bad_SS")

modelFile(
    '("/data/cad/pdk_all/pdk_tsmc/pdk_tsmc_28/PDK/TSMC_new_iPDK/models/spectre/crn28hpcp_1d8_elk_v1d0_2p2_shrink0d9_embedded_usage.scs" "ssmacro_mos_moscap")
    '("/data/cad/pdk_all/pdk_tsmc/pdk_tsmc_28/PDK/TSMC_new_iPDK/models/spectre/crn28hpcp_1d8_elk_v1d0_2p2_shrink0d9_embedded_usage.scs" "ss_res_bip_dio_disres")
    '("/data/cad/pdk_all/pdk_tsmc/pdk_tsmc_28/PDK/TSMC_new_iPDK/models/spectre/crn28hpcp_1d8_elk_v1d0_2p2_shrink0d9_embedded_usage.scs" "pre_simu")
)
analysis('dc ?saveOppoint t)
analysis('tran ?stop "275n")

envOption('termDirectionMismatch "ignore" 'termMismatch "ignore")
saveOption( ?infoOptions list(list("modelParameter" "models" "rawfile" "" "" "" t) list("element" "inst" "rawfile" "" "" "" t) list("outputParameter" "output" "rawfile" "" "" "" t) list("designParamVals" "parameters" "rawfile" "" "" "" t) list("primitives" "primitives" "rawfile" "" "" "" t) list("subckts" "subckts" "rawfile" "" "" "" t) list("asserts" "assert" "rawfile" "" "" "" nil) list("extremeinfo" "all" "logfile" "" "yes" "" nil) list("allcap" "allcap" "file" "" "" "" nil) list("<Click_To_Add>" "none" "rawfile" "" "" "" nil) ) )
save('i "/xdrv_p/out")

out_file = outfile("results_bad_SS.csv")
fprintf(out_file "suite,corner,res_sec,vreg,temp,pmon,pvtp_sim,pvtn_sim,gt_pvtp,gt_pvtn,sim_pup,sim_pdn,excel_pup,excel_pdn\n")
drain(out_file)

; --- Sim 1/21: SS (ss_res_bip_dio_disres), Vreg=0.83V, Temp=50.0C, pvtp=250, pvtn=250 ---
printf("\n>>> [BAD] Running SS Sim 1/21: V=0.83V, T=50.0C, pvtp=250, pvtn=250 <<<\n")
desVar("tem" 50.0)
desVar("vreg" 0.83)
temp(50.0)
desVar("pvt0" 0)
desVar("pvt1" 1)
desVar("pvt2" 0)
desVar("pvt3" 1)
desVar("pvt4" 1)
desVar("pvt5" 1)
desVar("pvt6" 1)
desVar("pvt7" 1)
desVar("pvt8" 0)
desVar("pvt9" 0)
desVar("pvt10" 0)
desVar("pvt11" 0)
desVar("pvt12" 0)
desVar("pvt13" 0)
desVar("pvtn0" 0)
desVar("pvtn1" 1)
desVar("pvtn2" 0)
desVar("pvtn3" 1)
desVar("pvtn4" 1)
desVar("pvtn5" 1)
desVar("pvtn6" 1)
desVar("pvtn7" 1)
desVar("pvtn8" 0)
desVar("pvtn9" 0)
desVar("pvtn10" 0)
desVar("pvtn11" 0)
desVar("pvtn12" 0)
desVar("pvtn13" 0)
run()
selectResults('tran)
pup_val = average((clip((v("/vdd" ?result "tran") - v("/outn" ?result "tran")) 2e-07 2.5e-07) / clip(i("/xdrv_p/out" ?result "tran") 2e-07 2.5e-07)))
pdn_val = (average((clip(v("/outp" ?result "tran") 2e-07 2.5e-07) / clip(i("/xdrv_p/out" ?result "tran") 2e-07 2.5e-07))) * -1)
fprintf(out_file "SS,SS,ss_res_bip_dio_disres,0.83,50.0,221003350,250,250,251,251,%f,%f,50.57,49.74\n" pup_val pdn_val)
drain(out_file)
printf("Result -> pup=%f, pdn=%f (Excel: pup=50.57, pdn=49.74)\n" pup_val pdn_val)

; --- Sim 2/21: SS (ss_res_bip_dio_disres), Vreg=0.85V, Temp=51.5C, pvtp=251, pvtn=250 ---
printf("\n>>> [BAD] Running SS Sim 2/21: V=0.85V, T=51.5C, pvtp=251, pvtn=250 <<<\n")
desVar("tem" 51.5)
desVar("vreg" 0.85)
temp(51.5)
desVar("pvt0" 1)
desVar("pvt1" 1)
desVar("pvt2" 0)
desVar("pvt3" 1)
desVar("pvt4" 1)
desVar("pvt5" 1)
desVar("pvt6" 1)
desVar("pvt7" 1)
desVar("pvt8" 0)
desVar("pvt9" 0)
desVar("pvt10" 0)
desVar("pvt11" 0)
desVar("pvt12" 0)
desVar("pvt13" 0)
desVar("pvtn0" 0)
desVar("pvtn1" 1)
desVar("pvtn2" 0)
desVar("pvtn3" 1)
desVar("pvtn4" 1)
desVar("pvtn5" 1)
desVar("pvtn6" 1)
desVar("pvtn7" 1)
desVar("pvtn8" 0)
desVar("pvtn9" 0)
desVar("pvtn10" 0)
desVar("pvtn11" 0)
desVar("pvtn12" 0)
desVar("pvtn13" 0)
run()
selectResults('tran)
pup_val = average((clip((v("/vdd" ?result "tran") - v("/outn" ?result "tran")) 2e-07 2.5e-07) / clip(i("/xdrv_p/out" ?result "tran") 2e-07 2.5e-07)))
pdn_val = (average((clip(v("/outp" ?result "tran") 2e-07 2.5e-07) / clip(i("/xdrv_p/out" ?result "tran") 2e-07 2.5e-07))) * -1)
fprintf(out_file "SS,SS,ss_res_bip_dio_disres,0.85,51.5,232870150,251,250,251,251,%f,%f,50.21,49.51\n" pup_val pdn_val)
drain(out_file)
printf("Result -> pup=%f, pdn=%f (Excel: pup=50.21, pdn=49.51)\n" pup_val pdn_val)

; --- Sim 3/21: SS (ss_res_bip_dio_disres), Vreg=0.85V, Temp=69.0C, pvtp=251, pvtn=251 ---
printf("\n>>> [BAD] Running SS Sim 3/21: V=0.85V, T=69.0C, pvtp=251, pvtn=251 <<<\n")
desVar("tem" 69.0)
desVar("vreg" 0.85)
temp(69.0)
desVar("pvt0" 1)
desVar("pvt1" 1)
desVar("pvt2" 0)
desVar("pvt3" 1)
desVar("pvt4" 1)
desVar("pvt5" 1)
desVar("pvt6" 1)
desVar("pvt7" 1)
desVar("pvt8" 0)
desVar("pvt9" 0)
desVar("pvt10" 0)
desVar("pvt11" 0)
desVar("pvt12" 0)
desVar("pvt13" 0)
desVar("pvtn0" 1)
desVar("pvtn1" 1)
desVar("pvtn2" 0)
desVar("pvtn3" 1)
desVar("pvtn4" 1)
desVar("pvtn5" 1)
desVar("pvtn6" 1)
desVar("pvtn7" 1)
desVar("pvtn8" 0)
desVar("pvtn9" 0)
desVar("pvtn10" 0)
desVar("pvtn11" 0)
desVar("pvtn12" 0)
desVar("pvtn13" 0)
run()
selectResults('tran)
pup_val = average((clip((v("/vdd" ?result "tran") - v("/outn" ?result "tran")) 2e-07 2.5e-07) / clip(i("/xdrv_p/out" ?result "tran") 2e-07 2.5e-07)))
pdn_val = (average((clip(v("/outp" ?result "tran") 2e-07 2.5e-07) / clip(i("/xdrv_p/out" ?result "tran") 2e-07 2.5e-07))) * -1)
fprintf(out_file "SS,SS,ss_res_bip_dio_disres,0.85,69.0,231846040,251,251,252,251,%f,%f,49.63,49.9\n" pup_val pdn_val)
drain(out_file)
printf("Result -> pup=%f, pdn=%f (Excel: pup=49.63, pdn=49.9)\n" pup_val pdn_val)

; --- Sim 4/21: SS (ss_res_bip_dio_disres), Vreg=0.87V, Temp=42.5C, pvtp=249, pvtn=249 ---
printf("\n>>> [BAD] Running SS Sim 4/21: V=0.87V, T=42.5C, pvtp=249, pvtn=249 <<<\n")
desVar("tem" 42.5)
desVar("vreg" 0.87)
temp(42.5)
desVar("pvt0" 1)
desVar("pvt1" 0)
desVar("pvt2" 0)
desVar("pvt3" 1)
desVar("pvt4" 1)
desVar("pvt5" 1)
desVar("pvt6" 1)
desVar("pvt7" 1)
desVar("pvt8" 0)
desVar("pvt9" 0)
desVar("pvt10" 0)
desVar("pvt11" 0)
desVar("pvt12" 0)
desVar("pvt13" 0)
desVar("pvtn0" 1)
desVar("pvtn1" 0)
desVar("pvtn2" 0)
desVar("pvtn3" 1)
desVar("pvtn4" 1)
desVar("pvtn5" 1)
desVar("pvtn6" 1)
desVar("pvtn7" 1)
desVar("pvtn8" 0)
desVar("pvtn9" 0)
desVar("pvtn10" 0)
desVar("pvtn11" 0)
desVar("pvtn12" 0)
desVar("pvtn13" 0)
run()
selectResults('tran)
pup_val = average((clip((v("/vdd" ?result "tran") - v("/outn" ?result "tran")) 2e-07 2.5e-07) / clip(i("/xdrv_p/out" ?result "tran") 2e-07 2.5e-07)))
pdn_val = (average((clip(v("/outp" ?result "tran") 2e-07 2.5e-07) / clip(i("/xdrv_p/out" ?result "tran") 2e-07 2.5e-07))) * -1)
fprintf(out_file "SS,SS,ss_res_bip_dio_disres,0.87,42.5,245566740,249,249,250,249,%f,%f,49.61,50.23\n" pup_val pdn_val)
drain(out_file)
printf("Result -> pup=%f, pdn=%f (Excel: pup=49.61, pdn=50.23)\n" pup_val pdn_val)

; --- Sim 5/21: SS (ss_res_bip_dio_disres), Vreg=0.87V, Temp=63.0C, pvtp=250, pvtn=249 ---
printf("\n>>> [BAD] Running SS Sim 5/21: V=0.87V, T=63.0C, pvtp=250, pvtn=249 <<<\n")
desVar("tem" 63.0)
desVar("vreg" 0.87)
temp(63.0)
desVar("pvt0" 0)
desVar("pvt1" 1)
desVar("pvt2" 0)
desVar("pvt3" 1)
desVar("pvt4" 1)
desVar("pvt5" 1)
desVar("pvt6" 1)
desVar("pvt7" 1)
desVar("pvt8" 0)
desVar("pvt9" 0)
desVar("pvt10" 0)
desVar("pvt11" 0)
desVar("pvt12" 0)
desVar("pvt13" 0)
desVar("pvtn0" 1)
desVar("pvtn1" 0)
desVar("pvtn2" 0)
desVar("pvtn3" 1)
desVar("pvtn4" 1)
desVar("pvtn5" 1)
desVar("pvtn6" 1)
desVar("pvtn7" 1)
desVar("pvtn8" 0)
desVar("pvtn9" 0)
desVar("pvtn10" 0)
desVar("pvtn11" 0)
desVar("pvtn12" 0)
desVar("pvtn13" 0)
run()
selectResults('tran)
pup_val = average((clip((v("/vdd" ?result "tran") - v("/outn" ?result "tran")) 2e-07 2.5e-07) / clip(i("/xdrv_p/out" ?result "tran") 2e-07 2.5e-07)))
pdn_val = (average((clip(v("/outp" ?result "tran") 2e-07 2.5e-07) / clip(i("/xdrv_p/out" ?result "tran") 2e-07 2.5e-07))) * -1)
fprintf(out_file "SS,SS,ss_res_bip_dio_disres,0.87,63.0,243546040,250,249,250,250,%f,%f,50.17,49.51\n" pup_val pdn_val)
drain(out_file)
printf("Result -> pup=%f, pdn=%f (Excel: pup=50.17, pdn=49.51)\n" pup_val pdn_val)

; --- Sim 6/21: SS (ss_res_bip_dio_disres), Vreg=0.87V, Temp=81.5C, pvtp=251, pvtn=250 ---
printf("\n>>> [BAD] Running SS Sim 6/21: V=0.87V, T=81.5C, pvtp=251, pvtn=250 <<<\n")
desVar("tem" 81.5)
desVar("vreg" 0.87)
temp(81.5)
desVar("pvt0" 1)
desVar("pvt1" 1)
desVar("pvt2" 0)
desVar("pvt3" 1)
desVar("pvt4" 1)
desVar("pvt5" 1)
desVar("pvt6" 1)
desVar("pvt7" 1)
desVar("pvt8" 0)
desVar("pvt9" 0)
desVar("pvt10" 0)
desVar("pvt11" 0)
desVar("pvt12" 0)
desVar("pvt13" 0)
desVar("pvtn0" 0)
desVar("pvtn1" 1)
desVar("pvtn2" 0)
desVar("pvtn3" 1)
desVar("pvtn4" 1)
desVar("pvtn5" 1)
desVar("pvtn6" 1)
desVar("pvtn7" 1)
desVar("pvtn8" 0)
desVar("pvtn9" 0)
desVar("pvtn10" 0)
desVar("pvtn11" 0)
desVar("pvtn12" 0)
desVar("pvtn13" 0)
run()
selectResults('tran)
pup_val = average((clip((v("/vdd" ?result "tran") - v("/outn" ?result "tran")) 2e-07 2.5e-07) / clip(i("/xdrv_p/out" ?result "tran") 2e-07 2.5e-07)))
pdn_val = (average((clip(v("/outp" ?result "tran") 2e-07 2.5e-07) / clip(i("/xdrv_p/out" ?result "tran") 2e-07 2.5e-07))) * -1)
fprintf(out_file "SS,SS,ss_res_bip_dio_disres,0.87,81.5,242051110,251,250,250,250,%f,%f,50.69,49.92\n" pup_val pdn_val)
drain(out_file)
printf("Result -> pup=%f, pdn=%f (Excel: pup=50.69, pdn=49.92)\n" pup_val pdn_val)

; --- Sim 7/21: SS (ss_res_bip_dio_disres), Vreg=0.87V, Temp=82.0C, pvtp=251, pvtn=250 ---
printf("\n>>> [BAD] Running SS Sim 7/21: V=0.87V, T=82.0C, pvtp=251, pvtn=250 <<<\n")
desVar("tem" 82.0)
desVar("vreg" 0.87)
temp(82.0)
desVar("pvt0" 1)
desVar("pvt1" 1)
desVar("pvt2" 0)
desVar("pvt3" 1)
desVar("pvt4" 1)
desVar("pvt5" 1)
desVar("pvt6" 1)
desVar("pvt7" 1)
desVar("pvt8" 0)
desVar("pvt9" 0)
desVar("pvt10" 0)
desVar("pvt11" 0)
desVar("pvt12" 0)
desVar("pvt13" 0)
desVar("pvtn0" 0)
desVar("pvtn1" 1)
desVar("pvtn2" 0)
desVar("pvtn3" 1)
desVar("pvtn4" 1)
desVar("pvtn5" 1)
desVar("pvtn6" 1)
desVar("pvtn7" 1)
desVar("pvtn8" 0)
desVar("pvtn9" 0)
desVar("pvtn10" 0)
desVar("pvtn11" 0)
desVar("pvtn12" 0)
desVar("pvtn13" 0)
run()
selectResults('tran)
pup_val = average((clip((v("/vdd" ?result "tran") - v("/outn" ?result "tran")) 2e-07 2.5e-07) / clip(i("/xdrv_p/out" ?result "tran") 2e-07 2.5e-07)))
pdn_val = (average((clip(v("/outp" ?result "tran") 2e-07 2.5e-07) / clip(i("/xdrv_p/out" ?result "tran") 2e-07 2.5e-07))) * -1)
fprintf(out_file "SS,SS,ss_res_bip_dio_disres,0.87,82.0,242022100,251,250,250,250,%f,%f,50.7,49.93\n" pup_val pdn_val)
drain(out_file)
printf("Result -> pup=%f, pdn=%f (Excel: pup=50.7, pdn=49.93)\n" pup_val pdn_val)

; --- Sim 8/21: SS (ss_res_bip_dio_disres), Vreg=0.89V, Temp=13.0C, pvtp=249, pvtn=248 ---
printf("\n>>> [BAD] Running SS Sim 8/21: V=0.89V, T=13.0C, pvtp=249, pvtn=248 <<<\n")
desVar("tem" 13.0)
desVar("vreg" 0.89)
temp(13.0)
desVar("pvt0" 1)
desVar("pvt1" 0)
desVar("pvt2" 0)
desVar("pvt3" 1)
desVar("pvt4" 1)
desVar("pvt5" 1)
desVar("pvt6" 1)
desVar("pvt7" 1)
desVar("pvt8" 0)
desVar("pvt9" 0)
desVar("pvt10" 0)
desVar("pvt11" 0)
desVar("pvt12" 0)
desVar("pvt13" 0)
desVar("pvtn0" 0)
desVar("pvtn1" 0)
desVar("pvtn2" 0)
desVar("pvtn3" 1)
desVar("pvtn4" 1)
desVar("pvtn5" 1)
desVar("pvtn6" 1)
desVar("pvtn7" 1)
desVar("pvtn8" 0)
desVar("pvtn9" 0)
desVar("pvtn10" 0)
desVar("pvtn11" 0)
desVar("pvtn12" 0)
desVar("pvtn13" 0)
run()
selectResults('tran)
pup_val = average((clip((v("/vdd" ?result "tran") - v("/outn" ?result "tran")) 2e-07 2.5e-07) / clip(i("/xdrv_p/out" ?result "tran") 2e-07 2.5e-07)))
pdn_val = (average((clip(v("/outp" ?result "tran") 2e-07 2.5e-07) / clip(i("/xdrv_p/out" ?result "tran") 2e-07 2.5e-07))) * -1)
fprintf(out_file "SS,SS,ss_res_bip_dio_disres,0.89,13.0,262219940,249,248,248,248,%f,%f,50.69,50.4\n" pup_val pdn_val)
drain(out_file)
printf("Result -> pup=%f, pdn=%f (Excel: pup=50.69, pdn=50.4)\n" pup_val pdn_val)

; --- Sim 9/21: SS (ss_res_bip_dio_disres), Vreg=0.89V, Temp=55.5C, pvtp=249, pvtn=249 ---
printf("\n>>> [BAD] Running SS Sim 9/21: V=0.89V, T=55.5C, pvtp=249, pvtn=249 <<<\n")
desVar("tem" 55.5)
desVar("vreg" 0.89)
temp(55.5)
desVar("pvt0" 1)
desVar("pvt1" 0)
desVar("pvt2" 0)
desVar("pvt3" 1)
desVar("pvt4" 1)
desVar("pvt5" 1)
desVar("pvt6" 1)
desVar("pvt7" 1)
desVar("pvt8" 0)
desVar("pvt9" 0)
desVar("pvt10" 0)
desVar("pvt11" 0)
desVar("pvt12" 0)
desVar("pvt13" 0)
desVar("pvtn0" 1)
desVar("pvtn1" 0)
desVar("pvtn2" 0)
desVar("pvtn3" 1)
desVar("pvtn4" 1)
desVar("pvtn5" 1)
desVar("pvtn6" 1)
desVar("pvtn7" 1)
desVar("pvtn8" 0)
desVar("pvtn9" 0)
desVar("pvtn10" 0)
desVar("pvtn11" 0)
desVar("pvtn12" 0)
desVar("pvtn13" 0)
run()
selectResults('tran)
pup_val = average((clip((v("/vdd" ?result "tran") - v("/outn" ?result "tran")) 2e-07 2.5e-07) / clip(i("/xdrv_p/out" ?result "tran") 2e-07 2.5e-07)))
pdn_val = (average((clip(v("/outp" ?result "tran") 2e-07 2.5e-07) / clip(i("/xdrv_p/out" ?result "tran") 2e-07 2.5e-07))) * -1)
fprintf(out_file "SS,SS,ss_res_bip_dio_disres,0.89,55.5,255672920,249,249,250,249,%f,%f,49.65,50.28\n" pup_val pdn_val)
drain(out_file)
printf("Result -> pup=%f, pdn=%f (Excel: pup=49.65, pdn=50.28)\n" pup_val pdn_val)

; --- Sim 10/21: SS (ss_res_bip_dio_disres), Vreg=0.91V, Temp=23.5C, pvtp=249, pvtn=248 ---
printf("\n>>> [BAD] Running SS Sim 10/21: V=0.91V, T=23.5C, pvtp=249, pvtn=248 <<<\n")
desVar("tem" 23.5)
desVar("vreg" 0.91)
temp(23.5)
desVar("pvt0" 1)
desVar("pvt1" 0)
desVar("pvt2" 0)
desVar("pvt3" 1)
desVar("pvt4" 1)
desVar("pvt5" 1)
desVar("pvt6" 1)
desVar("pvt7" 1)
desVar("pvt8" 0)
desVar("pvt9" 0)
desVar("pvt10" 0)
desVar("pvt11" 0)
desVar("pvt12" 0)
desVar("pvt13" 0)
desVar("pvtn0" 0)
desVar("pvtn1" 0)
desVar("pvtn2" 0)
desVar("pvtn3" 1)
desVar("pvtn4" 1)
desVar("pvtn5" 1)
desVar("pvtn6" 1)
desVar("pvtn7" 1)
desVar("pvtn8" 0)
desVar("pvtn9" 0)
desVar("pvtn10" 0)
desVar("pvtn11" 0)
desVar("pvtn12" 0)
desVar("pvtn13" 0)
run()
selectResults('tran)
pup_val = average((clip((v("/vdd" ?result "tran") - v("/outn" ?result "tran")) 2e-07 2.5e-07) / clip(i("/xdrv_p/out" ?result "tran") 2e-07 2.5e-07)))
pdn_val = (average((clip(v("/outp" ?result "tran") 2e-07 2.5e-07) / clip(i("/xdrv_p/out" ?result "tran") 2e-07 2.5e-07))) * -1)
fprintf(out_file "SS,SS,ss_res_bip_dio_disres,0.91,23.5,272692910,249,248,248,248,%f,%f,50.68,50.43\n" pup_val pdn_val)
drain(out_file)
printf("Result -> pup=%f, pdn=%f (Excel: pup=50.68, pdn=50.43)\n" pup_val pdn_val)

; --- Sim 11/21: SS (ss_res_bip_dio_disres), Vreg=0.91V, Temp=24.0C, pvtp=249, pvtn=248 ---
printf("\n>>> [BAD] Running SS Sim 11/21: V=0.91V, T=24.0C, pvtp=249, pvtn=248 <<<\n")
desVar("tem" 24.0)
desVar("vreg" 0.91)
temp(24.0)
desVar("pvt0" 1)
desVar("pvt1" 0)
desVar("pvt2" 0)
desVar("pvt3" 1)
desVar("pvt4" 1)
desVar("pvt5" 1)
desVar("pvt6" 1)
desVar("pvt7" 1)
desVar("pvt8" 0)
desVar("pvt9" 0)
desVar("pvt10" 0)
desVar("pvt11" 0)
desVar("pvt12" 0)
desVar("pvt13" 0)
desVar("pvtn0" 0)
desVar("pvtn1" 0)
desVar("pvtn2" 0)
desVar("pvtn3" 1)
desVar("pvtn4" 1)
desVar("pvtn5" 1)
desVar("pvtn6" 1)
desVar("pvtn7" 1)
desVar("pvtn8" 0)
desVar("pvtn9" 0)
desVar("pvtn10" 0)
desVar("pvtn11" 0)
desVar("pvtn12" 0)
desVar("pvtn13" 0)
run()
selectResults('tran)
pup_val = average((clip((v("/vdd" ?result "tran") - v("/outn" ?result "tran")) 2e-07 2.5e-07) / clip(i("/xdrv_p/out" ?result "tran") 2e-07 2.5e-07)))
pdn_val = (average((clip(v("/outp" ?result "tran") 2e-07 2.5e-07) / clip(i("/xdrv_p/out" ?result "tran") 2e-07 2.5e-07))) * -1)
fprintf(out_file "SS,SS,ss_res_bip_dio_disres,0.91,24.0,272590830,249,248,248,248,%f,%f,50.7,50.44\n" pup_val pdn_val)
drain(out_file)
printf("Result -> pup=%f, pdn=%f (Excel: pup=50.7, pdn=50.44)\n" pup_val pdn_val)

; --- Sim 12/21: SS (ss_res_bip_dio_disres), Vreg=0.91V, Temp=103.5C, pvtp=250, pvtn=250 ---
printf("\n>>> [BAD] Running SS Sim 12/21: V=0.91V, T=103.5C, pvtp=250, pvtn=250 <<<\n")
desVar("tem" 103.5)
desVar("vreg" 0.91)
temp(103.5)
desVar("pvt0" 0)
desVar("pvt1" 1)
desVar("pvt2" 0)
desVar("pvt3" 1)
desVar("pvt4" 1)
desVar("pvt5" 1)
desVar("pvt6" 1)
desVar("pvt7" 1)
desVar("pvt8" 0)
desVar("pvt9" 0)
desVar("pvt10" 0)
desVar("pvt11" 0)
desVar("pvt12" 0)
desVar("pvt13" 0)
desVar("pvtn0" 0)
desVar("pvtn1" 1)
desVar("pvtn2" 0)
desVar("pvtn3" 1)
desVar("pvtn4" 1)
desVar("pvtn5" 1)
desVar("pvtn6" 1)
desVar("pvtn7" 1)
desVar("pvtn8" 0)
desVar("pvtn9" 0)
desVar("pvtn10" 0)
desVar("pvtn11" 0)
desVar("pvtn12" 0)
desVar("pvtn13" 0)
run()
selectResults('tran)
pup_val = average((clip((v("/vdd" ?result "tran") - v("/outn" ?result "tran")) 2e-07 2.5e-07) / clip(i("/xdrv_p/out" ?result "tran") 2e-07 2.5e-07)))
pdn_val = (average((clip(v("/outp" ?result "tran") 2e-07 2.5e-07) / clip(i("/xdrv_p/out" ?result "tran") 2e-07 2.5e-07))) * -1)
fprintf(out_file "SS,SS,ss_res_bip_dio_disres,0.91,103.5,260532300,250,250,251,250,%f,%f,49.64,49.95\n" pup_val pdn_val)
drain(out_file)
printf("Result -> pup=%f, pdn=%f (Excel: pup=49.64, pdn=49.95)\n" pup_val pdn_val)

; --- Sim 13/21: SS (ss_res_bip_dio_disres), Vreg=0.93V, Temp=-15.0C, pvtp=243, pvtn=248 ---
printf("\n>>> [BAD] Running SS Sim 13/21: V=0.93V, T=-15.0C, pvtp=243, pvtn=248 <<<\n")
desVar("tem" -15.0)
desVar("vreg" 0.93)
temp(-15.0)
desVar("pvt0" 1)
desVar("pvt1" 1)
desVar("pvt2" 0)
desVar("pvt3" 0)
desVar("pvt4" 1)
desVar("pvt5" 1)
desVar("pvt6" 1)
desVar("pvt7" 1)
desVar("pvt8" 0)
desVar("pvt9" 0)
desVar("pvt10" 0)
desVar("pvt11" 0)
desVar("pvt12" 0)
desVar("pvt13" 0)
desVar("pvtn0" 0)
desVar("pvtn1" 0)
desVar("pvtn2" 0)
desVar("pvtn3" 1)
desVar("pvtn4" 1)
desVar("pvtn5" 1)
desVar("pvtn6" 1)
desVar("pvtn7" 1)
desVar("pvtn8" 0)
desVar("pvtn9" 0)
desVar("pvtn10" 0)
desVar("pvtn11" 0)
desVar("pvtn12" 0)
desVar("pvtn13" 0)
run()
selectResults('tran)
pup_val = average((clip((v("/vdd" ?result "tran") - v("/outn" ?result "tran")) 2e-07 2.5e-07) / clip(i("/xdrv_p/out" ?result "tran") 2e-07 2.5e-07)))
pdn_val = (average((clip(v("/outp" ?result "tran") 2e-07 2.5e-07) / clip(i("/xdrv_p/out" ?result "tran") 2e-07 2.5e-07))) * -1)
fprintf(out_file "SS,SS,ss_res_bip_dio_disres,0.93,-15.0,295537790,243,248,243,243,%f,%f,50.48,50.29\n" pup_val pdn_val)
drain(out_file)
printf("Result -> pup=%f, pdn=%f (Excel: pup=50.48, pdn=50.29)\n" pup_val pdn_val)

; --- Sim 14/21: SS (ss_res_bip_dio_disres), Vreg=0.93V, Temp=-14.5C, pvtp=248, pvtn=248 ---
printf("\n>>> [BAD] Running SS Sim 14/21: V=0.93V, T=-14.5C, pvtp=248, pvtn=248 <<<\n")
desVar("tem" -14.5)
desVar("vreg" 0.93)
temp(-14.5)
desVar("pvt0" 0)
desVar("pvt1" 0)
desVar("pvt2" 0)
desVar("pvt3" 1)
desVar("pvt4" 1)
desVar("pvt5" 1)
desVar("pvt6" 1)
desVar("pvt7" 1)
desVar("pvt8" 0)
desVar("pvt9" 0)
desVar("pvt10" 0)
desVar("pvt11" 0)
desVar("pvt12" 0)
desVar("pvt13" 0)
desVar("pvtn0" 0)
desVar("pvtn1" 0)
desVar("pvtn2" 0)
desVar("pvtn3" 1)
desVar("pvtn4" 1)
desVar("pvtn5" 1)
desVar("pvtn6" 1)
desVar("pvtn7" 1)
desVar("pvtn8" 0)
desVar("pvtn9" 0)
desVar("pvtn10" 0)
desVar("pvtn11" 0)
desVar("pvtn12" 0)
desVar("pvtn13" 0)
run()
selectResults('tran)
pup_val = average((clip((v("/vdd" ?result "tran") - v("/outn" ?result "tran")) 2e-07 2.5e-07) / clip(i("/xdrv_p/out" ?result "tran") 2e-07 2.5e-07)))
pdn_val = (average((clip(v("/outp" ?result "tran") 2e-07 2.5e-07) / clip(i("/xdrv_p/out" ?result "tran") 2e-07 2.5e-07))) * -1)
fprintf(out_file "SS,SS,ss_res_bip_dio_disres,0.93,-14.5,295377060,248,248,243,243,%f,%f,50.5,50.3\n" pup_val pdn_val)
drain(out_file)
printf("Result -> pup=%f, pdn=%f (Excel: pup=50.5, pdn=50.3)\n" pup_val pdn_val)

; --- Sim 15/21: SS (ss_res_bip_dio_disres), Vreg=0.93V, Temp=40.5C, pvtp=249, pvtn=249 ---
printf("\n>>> [BAD] Running SS Sim 15/21: V=0.93V, T=40.5C, pvtp=249, pvtn=249 <<<\n")
desVar("tem" 40.5)
desVar("vreg" 0.93)
temp(40.5)
desVar("pvt0" 1)
desVar("pvt1" 0)
desVar("pvt2" 0)
desVar("pvt3" 1)
desVar("pvt4" 1)
desVar("pvt5" 1)
desVar("pvt6" 1)
desVar("pvt7" 1)
desVar("pvt8" 0)
desVar("pvt9" 0)
desVar("pvt10" 0)
desVar("pvt11" 0)
desVar("pvt12" 0)
desVar("pvt13" 0)
desVar("pvtn0" 1)
desVar("pvtn1" 0)
desVar("pvtn2" 0)
desVar("pvtn3" 1)
desVar("pvtn4" 1)
desVar("pvtn5" 1)
desVar("pvtn6" 1)
desVar("pvtn7" 1)
desVar("pvtn8" 0)
desVar("pvtn9" 0)
desVar("pvtn10" 0)
desVar("pvtn11" 0)
desVar("pvtn12" 0)
desVar("pvtn13" 0)
run()
selectResults('tran)
pup_val = average((clip((v("/vdd" ?result "tran") - v("/outn" ?result "tran")) 2e-07 2.5e-07) / clip(i("/xdrv_p/out" ?result "tran") 2e-07 2.5e-07)))
pdn_val = (average((clip(v("/outp" ?result "tran") 2e-07 2.5e-07) / clip(i("/xdrv_p/out" ?result "tran") 2e-07 2.5e-07))) * -1)
fprintf(out_file "SS,SS,ss_res_bip_dio_disres,0.93,40.5,280946220,249,249,249,248,%f,%f,49.76,50.62\n" pup_val pdn_val)
drain(out_file)
printf("Result -> pup=%f, pdn=%f (Excel: pup=49.76, pdn=50.62)\n" pup_val pdn_val)

; --- Sim 16/21: SS (ss_res_bip_dio_disres), Vreg=0.95V, Temp=1.5C, pvtp=122, pvtn=248 ---
printf("\n>>> [BAD] Running SS Sim 16/21: V=0.95V, T=1.5C, pvtp=122, pvtn=248 <<<\n")
desVar("tem" 1.5)
desVar("vreg" 0.95)
temp(1.5)
desVar("pvt0" 0)
desVar("pvt1" 1)
desVar("pvt2" 0)
desVar("pvt3" 1)
desVar("pvt4" 1)
desVar("pvt5" 1)
desVar("pvt6" 1)
desVar("pvt7" 0)
desVar("pvt8" 0)
desVar("pvt9" 0)
desVar("pvt10" 0)
desVar("pvt11" 0)
desVar("pvt12" 0)
desVar("pvt13" 0)
desVar("pvtn0" 0)
desVar("pvtn1" 0)
desVar("pvtn2" 0)
desVar("pvtn3" 1)
desVar("pvtn4" 1)
desVar("pvtn5" 1)
desVar("pvtn6" 1)
desVar("pvtn7" 1)
desVar("pvtn8" 0)
desVar("pvtn9" 0)
desVar("pvtn10" 0)
desVar("pvtn11" 0)
desVar("pvtn12" 0)
desVar("pvtn13" 0)
run()
selectResults('tran)
pup_val = average((clip((v("/vdd" ?result "tran") - v("/outn" ?result "tran")) 2e-07 2.5e-07) / clip(i("/xdrv_p/out" ?result "tran") 2e-07 2.5e-07)))
pdn_val = (average((clip(v("/outp" ?result "tran") 2e-07 2.5e-07) / clip(i("/xdrv_p/out" ?result "tran") 2e-07 2.5e-07))) * -1)
fprintf(out_file "SS,SS,ss_res_bip_dio_disres,0.95,1.5,303165450,122,248,248,248,%f,%f,49.58,49.51\n" pup_val pdn_val)
drain(out_file)
printf("Result -> pup=%f, pdn=%f (Excel: pup=49.58, pdn=49.51)\n" pup_val pdn_val)

; --- Sim 17/21: SS (ss_res_bip_dio_disres), Vreg=0.95V, Temp=51.5C, pvtp=249, pvtn=249 ---
printf("\n>>> [BAD] Running SS Sim 17/21: V=0.95V, T=51.5C, pvtp=249, pvtn=249 <<<\n")
desVar("tem" 51.5)
desVar("vreg" 0.95)
temp(51.5)
desVar("pvt0" 1)
desVar("pvt1" 0)
desVar("pvt2" 0)
desVar("pvt3" 1)
desVar("pvt4" 1)
desVar("pvt5" 1)
desVar("pvt6" 1)
desVar("pvt7" 1)
desVar("pvt8" 0)
desVar("pvt9" 0)
desVar("pvt10" 0)
desVar("pvt11" 0)
desVar("pvt12" 0)
desVar("pvt13" 0)
desVar("pvtn0" 1)
desVar("pvtn1" 0)
desVar("pvtn2" 0)
desVar("pvtn3" 1)
desVar("pvtn4" 1)
desVar("pvtn5" 1)
desVar("pvtn6" 1)
desVar("pvtn7" 1)
desVar("pvtn8" 0)
desVar("pvtn9" 0)
desVar("pvtn10" 0)
desVar("pvtn11" 0)
desVar("pvtn12" 0)
desVar("pvtn13" 0)
run()
selectResults('tran)
pup_val = average((clip((v("/vdd" ?result "tran") - v("/outn" ?result "tran")) 2e-07 2.5e-07) / clip(i("/xdrv_p/out" ?result "tran") 2e-07 2.5e-07)))
pdn_val = (average((clip(v("/outp" ?result "tran") 2e-07 2.5e-07) / clip(i("/xdrv_p/out" ?result "tran") 2e-07 2.5e-07))) * -1)
fprintf(out_file "SS,SS,ss_res_bip_dio_disres,0.95,51.5,289636140,249,249,249,248,%f,%f,49.84,50.69\n" pup_val pdn_val)
drain(out_file)
printf("Result -> pup=%f, pdn=%f (Excel: pup=49.84, pdn=50.69)\n" pup_val pdn_val)

; --- Sim 18/21: SS (ss_res_bip_dio_disres), Vreg=0.95V, Temp=83.0C, pvtp=249, pvtn=249 ---
printf("\n>>> [BAD] Running SS Sim 18/21: V=0.95V, T=83.0C, pvtp=249, pvtn=249 <<<\n")
desVar("tem" 83.0)
desVar("vreg" 0.95)
temp(83.0)
desVar("pvt0" 1)
desVar("pvt1" 0)
desVar("pvt2" 0)
desVar("pvt3" 1)
desVar("pvt4" 1)
desVar("pvt5" 1)
desVar("pvt6" 1)
desVar("pvt7" 1)
desVar("pvt8" 0)
desVar("pvt9" 0)
desVar("pvt10" 0)
desVar("pvt11" 0)
desVar("pvt12" 0)
desVar("pvt13" 0)
desVar("pvtn0" 1)
desVar("pvtn1" 0)
desVar("pvtn2" 0)
desVar("pvtn3" 1)
desVar("pvtn4" 1)
desVar("pvtn5" 1)
desVar("pvtn6" 1)
desVar("pvtn7" 1)
desVar("pvtn8" 0)
desVar("pvtn9" 0)
desVar("pvtn10" 0)
desVar("pvtn11" 0)
desVar("pvtn12" 0)
desVar("pvtn13" 0)
run()
selectResults('tran)
pup_val = average((clip((v("/vdd" ?result "tran") - v("/outn" ?result "tran")) 2e-07 2.5e-07) / clip(i("/xdrv_p/out" ?result "tran") 2e-07 2.5e-07)))
pdn_val = (average((clip(v("/outp" ?result "tran") 2e-07 2.5e-07) / clip(i("/xdrv_p/out" ?result "tran") 2e-07 2.5e-07))) * -1)
fprintf(out_file "SS,SS,ss_res_bip_dio_disres,0.95,83.0,283223850,249,249,250,249,%f,%f,49.61,50.32\n" pup_val pdn_val)
drain(out_file)
printf("Result -> pup=%f, pdn=%f (Excel: pup=49.61, pdn=50.32)\n" pup_val pdn_val)

; --- Sim 19/21: SS (ss_res_bip_dio_disres), Vreg=0.99V, Temp=-30.5C, pvtp=242, pvtn=123 ---
printf("\n>>> [BAD] Running SS Sim 19/21: V=0.99V, T=-30.5C, pvtp=242, pvtn=123 <<<\n")
desVar("tem" -30.5)
desVar("vreg" 0.99)
temp(-30.5)
desVar("pvt0" 0)
desVar("pvt1" 1)
desVar("pvt2" 0)
desVar("pvt3" 0)
desVar("pvt4" 1)
desVar("pvt5" 1)
desVar("pvt6" 1)
desVar("pvt7" 1)
desVar("pvt8" 0)
desVar("pvt9" 0)
desVar("pvt10" 0)
desVar("pvt11" 0)
desVar("pvt12" 0)
desVar("pvt13" 0)
desVar("pvtn0" 1)
desVar("pvtn1" 1)
desVar("pvtn2" 0)
desVar("pvtn3" 1)
desVar("pvtn4" 1)
desVar("pvtn5" 1)
desVar("pvtn6" 1)
desVar("pvtn7" 0)
desVar("pvtn8" 0)
desVar("pvtn9" 0)
desVar("pvtn10" 0)
desVar("pvtn11" 0)
desVar("pvtn12" 0)
desVar("pvtn13" 0)
run()
selectResults('tran)
pup_val = average((clip((v("/vdd" ?result "tran") - v("/outn" ?result "tran")) 2e-07 2.5e-07) / clip(i("/xdrv_p/out" ?result "tran") 2e-07 2.5e-07)))
pdn_val = (average((clip(v("/outp" ?result "tran") 2e-07 2.5e-07) / clip(i("/xdrv_p/out" ?result "tran") 2e-07 2.5e-07))) * -1)
fprintf(out_file "SS,SS,ss_res_bip_dio_disres,0.99,-30.5,341993810,242,123,242,242,%f,%f,50.58,50.54\n" pup_val pdn_val)
drain(out_file)
printf("Result -> pup=%f, pdn=%f (Excel: pup=50.58, pdn=50.54)\n" pup_val pdn_val)

; --- Sim 20/21: SS (ss_res_bip_dio_disres), Vreg=0.99V, Temp=-30.0C, pvtp=243, pvtn=123 ---
printf("\n>>> [BAD] Running SS Sim 20/21: V=0.99V, T=-30.0C, pvtp=243, pvtn=123 <<<\n")
desVar("tem" -30.0)
desVar("vreg" 0.99)
temp(-30.0)
desVar("pvt0" 1)
desVar("pvt1" 1)
desVar("pvt2" 0)
desVar("pvt3" 0)
desVar("pvt4" 1)
desVar("pvt5" 1)
desVar("pvt6" 1)
desVar("pvt7" 1)
desVar("pvt8" 0)
desVar("pvt9" 0)
desVar("pvt10" 0)
desVar("pvt11" 0)
desVar("pvt12" 0)
desVar("pvt13" 0)
desVar("pvtn0" 1)
desVar("pvtn1" 1)
desVar("pvtn2" 0)
desVar("pvtn3" 1)
desVar("pvtn4" 1)
desVar("pvtn5" 1)
desVar("pvtn6" 1)
desVar("pvtn7" 0)
desVar("pvtn8" 0)
desVar("pvtn9" 0)
desVar("pvtn10" 0)
desVar("pvtn11" 0)
desVar("pvtn12" 0)
desVar("pvtn13" 0)
run()
selectResults('tran)
pup_val = average((clip((v("/vdd" ?result "tran") - v("/outn" ?result "tran")) 2e-07 2.5e-07) / clip(i("/xdrv_p/out" ?result "tran") 2e-07 2.5e-07)))
pdn_val = (average((clip(v("/outp" ?result "tran") 2e-07 2.5e-07) / clip(i("/xdrv_p/out" ?result "tran") 2e-07 2.5e-07))) * -1)
fprintf(out_file "SS,SS,ss_res_bip_dio_disres,0.99,-30.0,341749440,243,123,242,242,%f,%f,50.6,50.56\n" pup_val pdn_val)
drain(out_file)
printf("Result -> pup=%f, pdn=%f (Excel: pup=50.6, pdn=50.56)\n" pup_val pdn_val)

; --- Sim 21/21: SS (ss_res_bip_dio_disres), Vreg=0.99V, Temp=115.5C, pvtp=250, pvtn=249 ---
printf("\n>>> [BAD] Running SS Sim 21/21: V=0.99V, T=115.5C, pvtp=250, pvtn=249 <<<\n")
desVar("tem" 115.5)
desVar("vreg" 0.99)
temp(115.5)
desVar("pvt0" 0)
desVar("pvt1" 1)
desVar("pvt2" 0)
desVar("pvt3" 1)
desVar("pvt4" 1)
desVar("pvt5" 1)
desVar("pvt6" 1)
desVar("pvt7" 1)
desVar("pvt8" 0)
desVar("pvt9" 0)
desVar("pvt10" 0)
desVar("pvt11" 0)
desVar("pvt12" 0)
desVar("pvt13" 0)
desVar("pvtn0" 1)
desVar("pvtn1" 0)
desVar("pvtn2" 0)
desVar("pvtn3" 1)
desVar("pvtn4" 1)
desVar("pvtn5" 1)
desVar("pvtn6" 1)
desVar("pvtn7" 1)
desVar("pvtn8" 0)
desVar("pvtn9" 0)
desVar("pvtn10" 0)
desVar("pvtn11" 0)
desVar("pvtn12" 0)
desVar("pvtn13" 0)
run()
selectResults('tran)
pup_val = average((clip((v("/vdd" ?result "tran") - v("/outn" ?result "tran")) 2e-07 2.5e-07) / clip(i("/xdrv_p/out" ?result "tran") 2e-07 2.5e-07)))
pdn_val = (average((clip(v("/outp" ?result "tran") 2e-07 2.5e-07) / clip(i("/xdrv_p/out" ?result "tran") 2e-07 2.5e-07))) * -1)
fprintf(out_file "SS,SS,ss_res_bip_dio_disres,0.99,115.5,295704200,250,249,250,250,%f,%f,50.13,49.51\n" pup_val pdn_val)
drain(out_file)
printf("Result -> pup=%f, pdn=%f (Excel: pup=50.13, pdn=49.51)\n" pup_val pdn_val)

close(out_file)
printf("\n=== BAD SS Complete! Results in results_bad_SS.csv ===\n")
exit()
