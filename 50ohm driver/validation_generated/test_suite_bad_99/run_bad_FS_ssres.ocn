; -----------------------------------------------------------------------------
; Cadence Spectre OCEAN Script: BAD - FS_ssres
; PDK Model: TSMC 28nm 1.8V (crn28hpcp_1d8_elk...)
; MOS Section: fsmacro_mos_moscap | Resistor Section: ss_res_bip_dio_disres
; -----------------------------------------------------------------------------
simulator('spectre)
design("tsmc28_tx_tb" "tx_drv_ML" "schematic_seriliazer_top")
resultsDir("./ocean_bad_FS_ssres")

modelFile(
    '("/data/cad/pdk_all/pdk_tsmc/pdk_tsmc_28/PDK/TSMC_new_iPDK/models/spectre/crn28hpcp_1d8_elk_v1d0_2p2_shrink0d9_embedded_usage.scs" "fsmacro_mos_moscap")
    '("/data/cad/pdk_all/pdk_tsmc/pdk_tsmc_28/PDK/TSMC_new_iPDK/models/spectre/crn28hpcp_1d8_elk_v1d0_2p2_shrink0d9_embedded_usage.scs" "ss_res_bip_dio_disres")
    '("/data/cad/pdk_all/pdk_tsmc/pdk_tsmc_28/PDK/TSMC_new_iPDK/models/spectre/crn28hpcp_1d8_elk_v1d0_2p2_shrink0d9_embedded_usage.scs" "pre_simu")
)
analysis('dc ?saveOppoint t)
analysis('tran ?stop "275n")

envOption('termDirectionMismatch "ignore" 'termMismatch "ignore")
saveOption( ?infoOptions list(list("modelParameter" "models" "rawfile" "" "" "" t) list("element" "inst" "rawfile" "" "" "" t) list("outputParameter" "output" "rawfile" "" "" "" t) list("designParamVals" "parameters" "rawfile" "" "" "" t) list("primitives" "primitives" "rawfile" "" "" "" t) list("subckts" "subckts" "rawfile" "" "" "" t) list("asserts" "assert" "rawfile" "" "" "" nil) list("extremeinfo" "all" "logfile" "" "yes" "" nil) list("allcap" "allcap" "file" "" "" "" nil) list("<Click_To_Add>" "none" "rawfile" "" "" "" nil) ) )
save('i "/xdrv_p/out")

out_file = outfile("results_bad_FS_ssres.csv")
fprintf(out_file "suite,corner,res_sec,vreg,temp,pmon,pvtp_sim,pvtn_sim,gt_pvtp,gt_pvtn,sim_pup,sim_pdn,excel_pup,excel_pdn\n")
drain(out_file)

; --- Sim 1/10: FS (ss_res_bip_dio_disres), Vreg=0.83V, Temp=19.5C, pvtp=29, pvtn=14 ---
printf("\n>>> [BAD] Running FS_ssres Sim 1/10: V=0.83V, T=19.5C, pvtp=29, pvtn=14 <<<\n")
desVar("tem" 19.5)
desVar("vreg" 0.83)
temp(19.5)
desVar("pvt0" 1)
desVar("pvt1" 0)
desVar("pvt2" 1)
desVar("pvt3" 1)
desVar("pvt4" 1)
desVar("pvt5" 0)
desVar("pvt6" 0)
desVar("pvt7" 0)
desVar("pvt8" 0)
desVar("pvt9" 0)
desVar("pvt10" 0)
desVar("pvt11" 0)
desVar("pvt12" 0)
desVar("pvt13" 0)
desVar("pvtn0" 0)
desVar("pvtn1" 1)
desVar("pvtn2" 1)
desVar("pvtn3" 1)
desVar("pvtn4" 0)
desVar("pvtn5" 0)
desVar("pvtn6" 0)
desVar("pvtn7" 0)
desVar("pvtn8" 0)
desVar("pvtn9" 0)
desVar("pvtn10" 0)
desVar("pvtn11" 0)
desVar("pvtn12" 0)
desVar("pvtn13" 0)
run()
selectResults('tran)
pup_val = average((clip((v("/vdd" ?result "tran") - v("/outn" ?result "tran")) 2e-07 2.5e-07) / clip(i("/xdrv_p/out" ?result "tran") 2e-07 2.5e-07)))
pdn_val = (average((clip(v("/outp" ?result "tran") 2e-07 2.5e-07) / clip(i("/xdrv_p/out" ?result "tran") 2e-07 2.5e-07))) * -1)
fprintf(out_file "FS_ssres,FS,ss_res_bip_dio_disres,0.83,19.5,262959760,29,14,28,14,%f,%f,50.94,50.24\n" pup_val pdn_val)
drain(out_file)
printf("Result -> pup=%f, pdn=%f (Excel: pup=50.94, pdn=50.24)\n" pup_val pdn_val)

; --- Sim 2/10: FS (ss_res_bip_dio_disres), Vreg=0.87V, Temp=84.0C, pvtp=61, pvtn=19 ---
printf("\n>>> [BAD] Running FS_ssres Sim 2/10: V=0.87V, T=84.0C, pvtp=61, pvtn=19 <<<\n")
desVar("tem" 84.0)
desVar("vreg" 0.87)
temp(84.0)
desVar("pvt0" 1)
desVar("pvt1" 0)
desVar("pvt2" 1)
desVar("pvt3" 1)
desVar("pvt4" 1)
desVar("pvt5" 1)
desVar("pvt6" 0)
desVar("pvt7" 0)
desVar("pvt8" 0)
desVar("pvt9" 0)
desVar("pvt10" 0)
desVar("pvt11" 0)
desVar("pvt12" 0)
desVar("pvt13" 0)
desVar("pvtn0" 1)
desVar("pvtn1" 1)
desVar("pvtn2" 0)
desVar("pvtn3" 0)
desVar("pvtn4" 1)
desVar("pvtn5" 0)
desVar("pvtn6" 0)
desVar("pvtn7" 0)
desVar("pvtn8" 0)
desVar("pvtn9" 0)
desVar("pvtn10" 0)
desVar("pvtn11" 0)
desVar("pvtn12" 0)
desVar("pvtn13" 0)
run()
selectResults('tran)
pup_val = average((clip((v("/vdd" ?result "tran") - v("/outn" ?result "tran")) 2e-07 2.5e-07) / clip(i("/xdrv_p/out" ?result "tran") 2e-07 2.5e-07)))
pdn_val = (average((clip(v("/outp" ?result "tran") 2e-07 2.5e-07) / clip(i("/xdrv_p/out" ?result "tran") 2e-07 2.5e-07))) * -1)
fprintf(out_file "FS_ssres,FS,ss_res_bip_dio_disres,0.87,84.0,282384400,61,19,29,19,%f,%f,49.805,49.8\n" pup_val pdn_val)
drain(out_file)
printf("Result -> pup=%f, pdn=%f (Excel: pup=49.805, pdn=49.8)\n" pup_val pdn_val)

; --- Sim 3/10: FS (ss_res_bip_dio_disres), Vreg=0.89V, Temp=-8.5C, pvtp=27, pvtn=30 ---
printf("\n>>> [BAD] Running FS_ssres Sim 3/10: V=0.89V, T=-8.5C, pvtp=27, pvtn=30 <<<\n")
desVar("tem" -8.5)
desVar("vreg" 0.89)
temp(-8.5)
desVar("pvt0" 1)
desVar("pvt1" 1)
desVar("pvt2" 0)
desVar("pvt3" 1)
desVar("pvt4" 1)
desVar("pvt5" 0)
desVar("pvt6" 0)
desVar("pvt7" 0)
desVar("pvt8" 0)
desVar("pvt9" 0)
desVar("pvt10" 0)
desVar("pvt11" 0)
desVar("pvt12" 0)
desVar("pvt13" 0)
desVar("pvtn0" 0)
desVar("pvtn1" 1)
desVar("pvtn2" 1)
desVar("pvtn3" 1)
desVar("pvtn4" 1)
desVar("pvtn5" 0)
desVar("pvtn6" 0)
desVar("pvtn7" 0)
desVar("pvtn8" 0)
desVar("pvtn9" 0)
desVar("pvtn10" 0)
desVar("pvtn11" 0)
desVar("pvtn12" 0)
desVar("pvtn13" 0)
run()
selectResults('tran)
pup_val = average((clip((v("/vdd" ?result "tran") - v("/outn" ?result "tran")) 2e-07 2.5e-07) / clip(i("/xdrv_p/out" ?result "tran") 2e-07 2.5e-07)))
pdn_val = (average((clip(v("/outp" ?result "tran") 2e-07 2.5e-07) / clip(i("/xdrv_p/out" ?result "tran") 2e-07 2.5e-07))) * -1)
fprintf(out_file "FS_ssres,FS,ss_res_bip_dio_disres,0.89,-8.5,312970330,27,30,27,14,%f,%f,50.079,49.01\n" pup_val pdn_val)
drain(out_file)
printf("Result -> pup=%f, pdn=%f (Excel: pup=50.079, pdn=49.01)\n" pup_val pdn_val)

; --- Sim 4/10: FS (ss_res_bip_dio_disres), Vreg=0.89V, Temp=-8.0C, pvtp=27, pvtn=30 ---
printf("\n>>> [BAD] Running FS_ssres Sim 4/10: V=0.89V, T=-8.0C, pvtp=27, pvtn=30 <<<\n")
desVar("tem" -8.0)
desVar("vreg" 0.89)
temp(-8.0)
desVar("pvt0" 1)
desVar("pvt1" 1)
desVar("pvt2" 0)
desVar("pvt3" 1)
desVar("pvt4" 1)
desVar("pvt5" 0)
desVar("pvt6" 0)
desVar("pvt7" 0)
desVar("pvt8" 0)
desVar("pvt9" 0)
desVar("pvt10" 0)
desVar("pvt11" 0)
desVar("pvt12" 0)
desVar("pvt13" 0)
desVar("pvtn0" 0)
desVar("pvtn1" 1)
desVar("pvtn2" 1)
desVar("pvtn3" 1)
desVar("pvtn4" 1)
desVar("pvtn5" 0)
desVar("pvtn6" 0)
desVar("pvtn7" 0)
desVar("pvtn8" 0)
desVar("pvtn9" 0)
desVar("pvtn10" 0)
desVar("pvtn11" 0)
desVar("pvtn12" 0)
desVar("pvtn13" 0)
run()
selectResults('tran)
pup_val = average((clip((v("/vdd" ?result "tran") - v("/outn" ?result "tran")) 2e-07 2.5e-07) / clip(i("/xdrv_p/out" ?result "tran") 2e-07 2.5e-07)))
pdn_val = (average((clip(v("/outp" ?result "tran") 2e-07 2.5e-07) / clip(i("/xdrv_p/out" ?result "tran") 2e-07 2.5e-07))) * -1)
fprintf(out_file "FS_ssres,FS,ss_res_bip_dio_disres,0.89,-8.0,312808390,27,30,27,14,%f,%f,50.096,49.02\n" pup_val pdn_val)
drain(out_file)
printf("Result -> pup=%f, pdn=%f (Excel: pup=50.096, pdn=49.02)\n" pup_val pdn_val)

; --- Sim 5/10: FS (ss_res_bip_dio_disres), Vreg=0.93V, Temp=70.0C, pvtp=29, pvtn=14 ---
printf("\n>>> [BAD] Running FS_ssres Sim 5/10: V=0.93V, T=70.0C, pvtp=29, pvtn=14 <<<\n")
desVar("tem" 70.0)
desVar("vreg" 0.93)
temp(70.0)
desVar("pvt0" 1)
desVar("pvt1" 0)
desVar("pvt2" 1)
desVar("pvt3" 1)
desVar("pvt4" 1)
desVar("pvt5" 0)
desVar("pvt6" 0)
desVar("pvt7" 0)
desVar("pvt8" 0)
desVar("pvt9" 0)
desVar("pvt10" 0)
desVar("pvt11" 0)
desVar("pvt12" 0)
desVar("pvt13" 0)
desVar("pvtn0" 0)
desVar("pvtn1" 1)
desVar("pvtn2" 1)
desVar("pvtn3" 1)
desVar("pvtn4" 0)
desVar("pvtn5" 0)
desVar("pvtn6" 0)
desVar("pvtn7" 0)
desVar("pvtn8" 0)
desVar("pvtn9" 0)
desVar("pvtn10" 0)
desVar("pvtn11" 0)
desVar("pvtn12" 0)
desVar("pvtn13" 0)
run()
selectResults('tran)
pup_val = average((clip((v("/vdd" ?result "tran") - v("/outn" ?result "tran")) 2e-07 2.5e-07) / clip(i("/xdrv_p/out" ?result "tran") 2e-07 2.5e-07)))
pdn_val = (average((clip(v("/outp" ?result "tran") 2e-07 2.5e-07) / clip(i("/xdrv_p/out" ?result "tran") 2e-07 2.5e-07))) * -1)
fprintf(out_file "FS_ssres,FS,ss_res_bip_dio_disres,0.93,70.0,319493000,29,14,28,14,%f,%f,50.891,50.43\n" pup_val pdn_val)
drain(out_file)
printf("Result -> pup=%f, pdn=%f (Excel: pup=50.891, pdn=50.43)\n" pup_val pdn_val)

; --- Sim 6/10: FS (ss_res_bip_dio_disres), Vreg=0.95V, Temp=20.0C, pvtp=30, pvtn=13 ---
printf("\n>>> [BAD] Running FS_ssres Sim 6/10: V=0.95V, T=20.0C, pvtp=30, pvtn=13 <<<\n")
desVar("tem" 20.0)
desVar("vreg" 0.95)
temp(20.0)
desVar("pvt0" 0)
desVar("pvt1" 1)
desVar("pvt2" 1)
desVar("pvt3" 1)
desVar("pvt4" 1)
desVar("pvt5" 0)
desVar("pvt6" 0)
desVar("pvt7" 0)
desVar("pvt8" 0)
desVar("pvt9" 0)
desVar("pvt10" 0)
desVar("pvt11" 0)
desVar("pvt12" 0)
desVar("pvt13" 0)
desVar("pvtn0" 1)
desVar("pvtn1" 0)
desVar("pvtn2" 1)
desVar("pvtn3" 1)
desVar("pvtn4" 0)
desVar("pvtn5" 0)
desVar("pvtn6" 0)
desVar("pvtn7" 0)
desVar("pvtn8" 0)
desVar("pvtn9" 0)
desVar("pvtn10" 0)
desVar("pvtn11" 0)
desVar("pvtn12" 0)
desVar("pvtn13" 0)
run()
selectResults('tran)
pup_val = average((clip((v("/vdd" ?result "tran") - v("/outn" ?result "tran")) 2e-07 2.5e-07) / clip(i("/xdrv_p/out" ?result "tran") 2e-07 2.5e-07)))
pdn_val = (average((clip(v("/outp" ?result "tran") 2e-07 2.5e-07) / clip(i("/xdrv_p/out" ?result "tran") 2e-07 2.5e-07))) * -1)
fprintf(out_file "FS_ssres,FS,ss_res_bip_dio_disres,0.95,20.0,345982300,30,13,27,13,%f,%f,50.094,50.82\n" pup_val pdn_val)
drain(out_file)
printf("Result -> pup=%f, pdn=%f (Excel: pup=50.094, pdn=50.82)\n" pup_val pdn_val)

; --- Sim 7/10: FS (ss_res_bip_dio_disres), Vreg=0.95V, Temp=45.0C, pvtp=27, pvtn=14 ---
printf("\n>>> [BAD] Running FS_ssres Sim 7/10: V=0.95V, T=45.0C, pvtp=27, pvtn=14 <<<\n")
desVar("tem" 45.0)
desVar("vreg" 0.95)
temp(45.0)
desVar("pvt0" 1)
desVar("pvt1" 1)
desVar("pvt2" 0)
desVar("pvt3" 1)
desVar("pvt4" 1)
desVar("pvt5" 0)
desVar("pvt6" 0)
desVar("pvt7" 0)
desVar("pvt8" 0)
desVar("pvt9" 0)
desVar("pvt10" 0)
desVar("pvt11" 0)
desVar("pvt12" 0)
desVar("pvt13" 0)
desVar("pvtn0" 0)
desVar("pvtn1" 1)
desVar("pvtn2" 1)
desVar("pvtn3" 1)
desVar("pvtn4" 0)
desVar("pvtn5" 0)
desVar("pvtn6" 0)
desVar("pvtn7" 0)
desVar("pvtn8" 0)
desVar("pvtn9" 0)
desVar("pvtn10" 0)
desVar("pvtn11" 0)
desVar("pvtn12" 0)
desVar("pvtn13" 0)
run()
selectResults('tran)
pup_val = average((clip((v("/vdd" ?result "tran") - v("/outn" ?result "tran")) 2e-07 2.5e-07) / clip(i("/xdrv_p/out" ?result "tran") 2e-07 2.5e-07)))
pdn_val = (average((clip(v("/outp" ?result "tran") 2e-07 2.5e-07) / clip(i("/xdrv_p/out" ?result "tran") 2e-07 2.5e-07))) * -1)
fprintf(out_file "FS_ssres,FS,ss_res_bip_dio_disres,0.95,45.0,337754460,27,14,28,14,%f,%f,49.616,49.77\n" pup_val pdn_val)
drain(out_file)
printf("Result -> pup=%f, pdn=%f (Excel: pup=49.616, pdn=49.77)\n" pup_val pdn_val)

; --- Sim 8/10: FS (ss_res_bip_dio_disres), Vreg=0.97V, Temp=83.5C, pvtp=28, pvtn=14 ---
printf("\n>>> [BAD] Running FS_ssres Sim 8/10: V=0.97V, T=83.5C, pvtp=28, pvtn=14 <<<\n")
desVar("tem" 83.5)
desVar("vreg" 0.97)
temp(83.5)
desVar("pvt0" 0)
desVar("pvt1" 0)
desVar("pvt2" 1)
desVar("pvt3" 1)
desVar("pvt4" 1)
desVar("pvt5" 0)
desVar("pvt6" 0)
desVar("pvt7" 0)
desVar("pvt8" 0)
desVar("pvt9" 0)
desVar("pvt10" 0)
desVar("pvt11" 0)
desVar("pvt12" 0)
desVar("pvt13" 0)
desVar("pvtn0" 0)
desVar("pvtn1" 1)
desVar("pvtn2" 1)
desVar("pvtn3" 1)
desVar("pvtn4" 0)
desVar("pvtn5" 0)
desVar("pvtn6" 0)
desVar("pvtn7" 0)
desVar("pvtn8" 0)
desVar("pvtn9" 0)
desVar("pvtn10" 0)
desVar("pvtn11" 0)
desVar("pvtn12" 0)
desVar("pvtn13" 0)
run()
selectResults('tran)
pup_val = average((clip((v("/vdd" ?result "tran") - v("/outn" ?result "tran")) 2e-07 2.5e-07) / clip(i("/xdrv_p/out" ?result "tran") 2e-07 2.5e-07)))
pdn_val = (average((clip(v("/outp" ?result "tran") 2e-07 2.5e-07) / clip(i("/xdrv_p/out" ?result "tran") 2e-07 2.5e-07))) * -1)
fprintf(out_file "FS_ssres,FS,ss_res_bip_dio_disres,0.97,83.5,338300330,28,14,29,14,%f,%f,49.609,50.41\n" pup_val pdn_val)
drain(out_file)
printf("Result -> pup=%f, pdn=%f (Excel: pup=49.609, pdn=50.41)\n" pup_val pdn_val)

; --- Sim 9/10: FS (ss_res_bip_dio_disres), Vreg=0.97V, Temp=84.0C, pvtp=31, pvtn=14 ---
printf("\n>>> [BAD] Running FS_ssres Sim 9/10: V=0.97V, T=84.0C, pvtp=31, pvtn=14 <<<\n")
desVar("tem" 84.0)
desVar("vreg" 0.97)
temp(84.0)
desVar("pvt0" 1)
desVar("pvt1" 1)
desVar("pvt2" 1)
desVar("pvt3" 1)
desVar("pvt4" 1)
desVar("pvt5" 0)
desVar("pvt6" 0)
desVar("pvt7" 0)
desVar("pvt8" 0)
desVar("pvt9" 0)
desVar("pvt10" 0)
desVar("pvt11" 0)
desVar("pvt12" 0)
desVar("pvt13" 0)
desVar("pvtn0" 0)
desVar("pvtn1" 1)
desVar("pvtn2" 1)
desVar("pvtn3" 1)
desVar("pvtn4" 0)
desVar("pvtn5" 0)
desVar("pvtn6" 0)
desVar("pvtn7" 0)
desVar("pvtn8" 0)
desVar("pvtn9" 0)
desVar("pvtn10" 0)
desVar("pvtn11" 0)
desVar("pvtn12" 0)
desVar("pvtn13" 0)
run()
selectResults('tran)
pup_val = average((clip((v("/vdd" ?result "tran") - v("/outn" ?result "tran")) 2e-07 2.5e-07) / clip(i("/xdrv_p/out" ?result "tran") 2e-07 2.5e-07)))
pdn_val = (average((clip(v("/outp" ?result "tran") 2e-07 2.5e-07) / clip(i("/xdrv_p/out" ?result "tran") 2e-07 2.5e-07))) * -1)
fprintf(out_file "FS_ssres,FS,ss_res_bip_dio_disres,0.97,84.0,338164650,31,14,29,14,%f,%f,49.632,50.42\n" pup_val pdn_val)
drain(out_file)
printf("Result -> pup=%f, pdn=%f (Excel: pup=49.632, pdn=50.42)\n" pup_val pdn_val)

; --- Sim 10/10: FS (ss_res_bip_dio_disres), Vreg=0.99V, Temp=57.5C, pvtp=27, pvtn=14 ---
printf("\n>>> [BAD] Running FS_ssres Sim 10/10: V=0.99V, T=57.5C, pvtp=27, pvtn=14 <<<\n")
desVar("tem" 57.5)
desVar("vreg" 0.99)
temp(57.5)
desVar("pvt0" 1)
desVar("pvt1" 1)
desVar("pvt2" 0)
desVar("pvt3" 1)
desVar("pvt4" 1)
desVar("pvt5" 0)
desVar("pvt6" 0)
desVar("pvt7" 0)
desVar("pvt8" 0)
desVar("pvt9" 0)
desVar("pvt10" 0)
desVar("pvt11" 0)
desVar("pvt12" 0)
desVar("pvt13" 0)
desVar("pvtn0" 0)
desVar("pvtn1" 1)
desVar("pvtn2" 1)
desVar("pvtn3" 1)
desVar("pvtn4" 0)
desVar("pvtn5" 0)
desVar("pvtn6" 0)
desVar("pvtn7" 0)
desVar("pvtn8" 0)
desVar("pvtn9" 0)
desVar("pvtn10" 0)
desVar("pvtn11" 0)
desVar("pvtn12" 0)
desVar("pvtn13" 0)
run()
selectResults('tran)
pup_val = average((clip((v("/vdd" ?result "tran") - v("/outn" ?result "tran")) 2e-07 2.5e-07) / clip(i("/xdrv_p/out" ?result "tran") 2e-07 2.5e-07)))
pdn_val = (average((clip(v("/outp" ?result "tran") 2e-07 2.5e-07) / clip(i("/xdrv_p/out" ?result "tran") 2e-07 2.5e-07))) * -1)
fprintf(out_file "FS_ssres,FS,ss_res_bip_dio_disres,0.99,57.5,357007910,27,14,29,14,%f,%f,50.997,49.78\n" pup_val pdn_val)
drain(out_file)
printf("Result -> pup=%f, pdn=%f (Excel: pup=50.997, pdn=49.78)\n" pup_val pdn_val)

close(out_file)
printf("\n=== BAD FS_ssres Complete! Results in results_bad_FS_ssres.csv ===\n")
exit()
