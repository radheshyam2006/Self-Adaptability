; -----------------------------------------------------------------------------
; Cadence Spectre OCEAN Script: BAD - SF_ssres
; PDK Model: TSMC 28nm 1.8V (crn28hpcp_1d8_elk...)
; MOS Section: sfmacro_mos_moscap | Resistor Section: ss_res_bip_dio_disres
; -----------------------------------------------------------------------------
simulator('spectre)
design("tsmc28_tx_tb" "tx_drv_ML" "schematic_seriliazer_top")
resultsDir("./ocean_bad_SF_ssres")

modelFile(
    '("/data/cad/pdk_all/pdk_tsmc/pdk_tsmc_28/PDK/TSMC_new_iPDK/models/spectre/crn28hpcp_1d8_elk_v1d0_2p2_shrink0d9_embedded_usage.scs" "sfmacro_mos_moscap")
    '("/data/cad/pdk_all/pdk_tsmc/pdk_tsmc_28/PDK/TSMC_new_iPDK/models/spectre/crn28hpcp_1d8_elk_v1d0_2p2_shrink0d9_embedded_usage.scs" "ss_res_bip_dio_disres")
    '("/data/cad/pdk_all/pdk_tsmc/pdk_tsmc_28/PDK/TSMC_new_iPDK/models/spectre/crn28hpcp_1d8_elk_v1d0_2p2_shrink0d9_embedded_usage.scs" "pre_simu")
)
analysis('dc ?saveOppoint t)
analysis('tran ?stop "275n")

envOption('termDirectionMismatch "ignore" 'termMismatch "ignore")
saveOption( ?infoOptions list(list("modelParameter" "models" "rawfile" "" "" "" t) list("element" "inst" "rawfile" "" "" "" t) list("outputParameter" "output" "rawfile" "" "" "" t) list("designParamVals" "parameters" "rawfile" "" "" "" t) list("primitives" "primitives" "rawfile" "" "" "" t) list("subckts" "subckts" "rawfile" "" "" "" t) list("asserts" "assert" "rawfile" "" "" "" nil) list("extremeinfo" "all" "logfile" "" "yes" "" nil) list("allcap" "allcap" "file" "" "" "" nil) list("<Click_To_Add>" "none" "rawfile" "" "" "" nil) ) )
save('i "/xdrv_p/out")

out_file = outfile("results_bad_SF_ssres.csv")
fprintf(out_file "suite,corner,res_sec,vreg,temp,pmon,pvtp_sim,pvtn_sim,gt_pvtp,gt_pvtn,sim_pup,sim_pdn,excel_pup,excel_pdn\n")
drain(out_file)

; --- Sim 1/9: SF (ss_res_bip_dio_disres), Vreg=0.81V, Temp=59.5C, pvtp=124, pvtn=125 ---
printf("\n>>> [BAD] Running SF_ssres Sim 1/9: V=0.81V, T=59.5C, pvtp=124, pvtn=125 <<<\n")
desVar("tem" 59.5)
desVar("vreg" 0.81)
temp(59.5)
desVar("pvt0" 0)
desVar("pvt1" 0)
desVar("pvt2" 1)
desVar("pvt3" 1)
desVar("pvt4" 1)
desVar("pvt5" 1)
desVar("pvt6" 1)
desVar("pvt7" 0)
desVar("pvt8" 0)
desVar("pvt9" 0)
desVar("pvt10" 0)
desVar("pvt11" 0)
desVar("pvt12" 0)
desVar("pvt13" 0)
desVar("pvtn0" 1)
desVar("pvtn1" 0)
desVar("pvtn2" 1)
desVar("pvtn3" 1)
desVar("pvtn4" 1)
desVar("pvtn5" 1)
desVar("pvtn6" 1)
desVar("pvtn7" 0)
desVar("pvtn8" 0)
desVar("pvtn9" 0)
desVar("pvtn10" 0)
desVar("pvtn11" 0)
desVar("pvtn12" 0)
desVar("pvtn13" 0)
run()
selectResults('tran)
pup_val = average((clip((v("/vdd" ?result "tran") - v("/outn" ?result "tran")) 2e-07 2.5e-07) / clip(i("/xdrv_p/out" ?result "tran") 2e-07 2.5e-07)))
pdn_val = (average((clip(v("/outp" ?result "tran") 2e-07 2.5e-07) / clip(i("/xdrv_p/out" ?result "tran") 2e-07 2.5e-07))) * -1)
fprintf(out_file "SF_ssres,SF,ss_res_bip_dio_disres,0.81,59.5,231707660,124,125,124,127,%f,%f,50.213,50.038\n" pup_val pdn_val)
drain(out_file)
printf("Result -> pup=%f, pdn=%f (Excel: pup=50.213, pdn=50.038)\n" pup_val pdn_val)

; --- Sim 2/9: SF (ss_res_bip_dio_disres), Vreg=0.85V, Temp=-18.5C, pvtp=122, pvtn=31 ---
printf("\n>>> [BAD] Running SF_ssres Sim 2/9: V=0.85V, T=-18.5C, pvtp=122, pvtn=31 <<<\n")
desVar("tem" -18.5)
desVar("vreg" 0.85)
temp(-18.5)
desVar("pvt0" 0)
desVar("pvt1" 1)
desVar("pvt2" 0)
desVar("pvt3" 1)
desVar("pvt4" 1)
desVar("pvt5" 1)
desVar("pvt6" 1)
desVar("pvt7" 0)
desVar("pvt8" 0)
desVar("pvt9" 0)
desVar("pvt10" 0)
desVar("pvt11" 0)
desVar("pvt12" 0)
desVar("pvt13" 0)
desVar("pvtn0" 1)
desVar("pvtn1" 1)
desVar("pvtn2" 1)
desVar("pvtn3" 1)
desVar("pvtn4" 1)
desVar("pvtn5" 0)
desVar("pvtn6" 0)
desVar("pvtn7" 0)
desVar("pvtn8" 0)
desVar("pvtn9" 0)
desVar("pvtn10" 0)
desVar("pvtn11" 0)
desVar("pvtn12" 0)
desVar("pvtn13" 0)
run()
selectResults('tran)
pup_val = average((clip((v("/vdd" ?result "tran") - v("/outn" ?result "tran")) 2e-07 2.5e-07) / clip(i("/xdrv_p/out" ?result "tran") 2e-07 2.5e-07)))
pdn_val = (average((clip(v("/outp" ?result "tran") 2e-07 2.5e-07) / clip(i("/xdrv_p/out" ?result "tran") 2e-07 2.5e-07))) * -1)
fprintf(out_file "SF_ssres,SF,ss_res_bip_dio_disres,0.85,-18.5,268090700,122,31,122,124,%f,%f,50.213,49.847\n" pup_val pdn_val)
drain(out_file)
printf("Result -> pup=%f, pdn=%f (Excel: pup=50.213, pdn=49.847)\n" pup_val pdn_val)

; --- Sim 3/9: SF (ss_res_bip_dio_disres), Vreg=0.85V, Temp=-18.0C, pvtp=122, pvtn=31 ---
printf("\n>>> [BAD] Running SF_ssres Sim 3/9: V=0.85V, T=-18.0C, pvtp=122, pvtn=31 <<<\n")
desVar("tem" -18.0)
desVar("vreg" 0.85)
temp(-18.0)
desVar("pvt0" 0)
desVar("pvt1" 1)
desVar("pvt2" 0)
desVar("pvt3" 1)
desVar("pvt4" 1)
desVar("pvt5" 1)
desVar("pvt6" 1)
desVar("pvt7" 0)
desVar("pvt8" 0)
desVar("pvt9" 0)
desVar("pvt10" 0)
desVar("pvt11" 0)
desVar("pvt12" 0)
desVar("pvt13" 0)
desVar("pvtn0" 1)
desVar("pvtn1" 1)
desVar("pvtn2" 1)
desVar("pvtn3" 1)
desVar("pvtn4" 1)
desVar("pvtn5" 0)
desVar("pvtn6" 0)
desVar("pvtn7" 0)
desVar("pvtn8" 0)
desVar("pvtn9" 0)
desVar("pvtn10" 0)
desVar("pvtn11" 0)
desVar("pvtn12" 0)
desVar("pvtn13" 0)
run()
selectResults('tran)
pup_val = average((clip((v("/vdd" ?result "tran") - v("/outn" ?result "tran")) 2e-07 2.5e-07) / clip(i("/xdrv_p/out" ?result "tran") 2e-07 2.5e-07)))
pdn_val = (average((clip(v("/outp" ?result "tran") 2e-07 2.5e-07) / clip(i("/xdrv_p/out" ?result "tran") 2e-07 2.5e-07))) * -1)
fprintf(out_file "SF_ssres,SF,ss_res_bip_dio_disres,0.85,-18.0,268033280,122,31,122,124,%f,%f,50.225,49.859\n" pup_val pdn_val)
drain(out_file)
printf("Result -> pup=%f, pdn=%f (Excel: pup=50.225, pdn=49.859)\n" pup_val pdn_val)

; --- Sim 4/9: SF (ss_res_bip_dio_disres), Vreg=0.87V, Temp=25.5C, pvtp=122, pvtn=126 ---
printf("\n>>> [BAD] Running SF_ssres Sim 4/9: V=0.87V, T=25.5C, pvtp=122, pvtn=126 <<<\n")
desVar("tem" 25.5)
desVar("vreg" 0.87)
temp(25.5)
desVar("pvt0" 0)
desVar("pvt1" 1)
desVar("pvt2" 0)
desVar("pvt3" 1)
desVar("pvt4" 1)
desVar("pvt5" 1)
desVar("pvt6" 1)
desVar("pvt7" 0)
desVar("pvt8" 0)
desVar("pvt9" 0)
desVar("pvt10" 0)
desVar("pvt11" 0)
desVar("pvt12" 0)
desVar("pvt13" 0)
desVar("pvtn0" 0)
desVar("pvtn1" 1)
desVar("pvtn2" 1)
desVar("pvtn3" 1)
desVar("pvtn4" 1)
desVar("pvtn5" 1)
desVar("pvtn6" 1)
desVar("pvtn7" 0)
desVar("pvtn8" 0)
desVar("pvtn9" 0)
desVar("pvtn10" 0)
desVar("pvtn11" 0)
desVar("pvtn12" 0)
desVar("pvtn13" 0)
run()
selectResults('tran)
pup_val = average((clip((v("/vdd" ?result "tran") - v("/outn" ?result "tran")) 2e-07 2.5e-07) / clip(i("/xdrv_p/out" ?result "tran") 2e-07 2.5e-07)))
pdn_val = (average((clip(v("/outp" ?result "tran") 2e-07 2.5e-07) / clip(i("/xdrv_p/out" ?result "tran") 2e-07 2.5e-07))) * -1)
fprintf(out_file "SF_ssres,SF,ss_res_bip_dio_disres,0.87,25.5,272309260,122,126,123,127,%f,%f,48.993,48.674\n" pup_val pdn_val)
drain(out_file)
printf("Result -> pup=%f, pdn=%f (Excel: pup=48.993, pdn=48.674)\n" pup_val pdn_val)

; --- Sim 5/9: SF (ss_res_bip_dio_disres), Vreg=0.91V, Temp=19.5C, pvtp=123, pvtn=125 ---
printf("\n>>> [BAD] Running SF_ssres Sim 5/9: V=0.91V, T=19.5C, pvtp=123, pvtn=125 <<<\n")
desVar("tem" 19.5)
desVar("vreg" 0.91)
temp(19.5)
desVar("pvt0" 1)
desVar("pvt1" 1)
desVar("pvt2" 0)
desVar("pvt3" 1)
desVar("pvt4" 1)
desVar("pvt5" 1)
desVar("pvt6" 1)
desVar("pvt7" 0)
desVar("pvt8" 0)
desVar("pvt9" 0)
desVar("pvt10" 0)
desVar("pvt11" 0)
desVar("pvt12" 0)
desVar("pvt13" 0)
desVar("pvtn0" 1)
desVar("pvtn1" 0)
desVar("pvtn2" 1)
desVar("pvtn3" 1)
desVar("pvtn4" 1)
desVar("pvtn5" 1)
desVar("pvtn6" 1)
desVar("pvtn7" 0)
desVar("pvtn8" 0)
desVar("pvtn9" 0)
desVar("pvtn10" 0)
desVar("pvtn11" 0)
desVar("pvtn12" 0)
desVar("pvtn13" 0)
run()
selectResults('tran)
pup_val = average((clip((v("/vdd" ?result "tran") - v("/outn" ?result "tran")) 2e-07 2.5e-07) / clip(i("/xdrv_p/out" ?result "tran") 2e-07 2.5e-07)))
pdn_val = (average((clip(v("/outp" ?result "tran") 2e-07 2.5e-07) / clip(i("/xdrv_p/out" ?result "tran") 2e-07 2.5e-07))) * -1)
fprintf(out_file "SF_ssres,SF,ss_res_bip_dio_disres,0.91,19.5,298421360,123,125,121,124,%f,%f,51.835,50.126\n" pup_val pdn_val)
drain(out_file)
printf("Result -> pup=%f, pdn=%f (Excel: pup=51.835, pdn=50.126)\n" pup_val pdn_val)

; --- Sim 6/9: SF (ss_res_bip_dio_disres), Vreg=0.93V, Temp=117.5C, pvtp=250, pvtn=125 ---
printf("\n>>> [BAD] Running SF_ssres Sim 6/9: V=0.93V, T=117.5C, pvtp=250, pvtn=125 <<<\n")
desVar("tem" 117.5)
desVar("vreg" 0.93)
temp(117.5)
desVar("pvt0" 0)
desVar("pvt1" 1)
desVar("pvt2" 0)
desVar("pvt3" 1)
desVar("pvt4" 1)
desVar("pvt5" 1)
desVar("pvt6" 1)
desVar("pvt7" 1)
desVar("pvt8" 0)
desVar("pvt9" 0)
desVar("pvt10" 0)
desVar("pvt11" 0)
desVar("pvt12" 0)
desVar("pvt13" 0)
desVar("pvtn0" 1)
desVar("pvtn1" 0)
desVar("pvtn2" 1)
desVar("pvtn3" 1)
desVar("pvtn4" 1)
desVar("pvtn5" 1)
desVar("pvtn6" 1)
desVar("pvtn7" 0)
desVar("pvtn8" 0)
desVar("pvtn9" 0)
desVar("pvtn10" 0)
desVar("pvtn11" 0)
desVar("pvtn12" 0)
desVar("pvtn13" 0)
run()
selectResults('tran)
pup_val = average((clip((v("/vdd" ?result "tran") - v("/outn" ?result "tran")) 2e-07 2.5e-07) / clip(i("/xdrv_p/out" ?result "tran") 2e-07 2.5e-07)))
pdn_val = (average((clip(v("/outp" ?result "tran") 2e-07 2.5e-07) / clip(i("/xdrv_p/out" ?result "tran") 2e-07 2.5e-07))) * -1)
fprintf(out_file "SF_ssres,SF,ss_res_bip_dio_disres,0.93,117.5,288043480,250,125,123,125,%f,%f,51.689,51.378\n" pup_val pdn_val)
drain(out_file)
printf("Result -> pup=%f, pdn=%f (Excel: pup=51.689, pdn=51.378)\n" pup_val pdn_val)

; --- Sim 7/9: SF (ss_res_bip_dio_disres), Vreg=0.93V, Temp=118.0C, pvtp=250, pvtn=125 ---
printf("\n>>> [BAD] Running SF_ssres Sim 7/9: V=0.93V, T=118.0C, pvtp=250, pvtn=125 <<<\n")
desVar("tem" 118.0)
desVar("vreg" 0.93)
temp(118.0)
desVar("pvt0" 0)
desVar("pvt1" 1)
desVar("pvt2" 0)
desVar("pvt3" 1)
desVar("pvt4" 1)
desVar("pvt5" 1)
desVar("pvt6" 1)
desVar("pvt7" 1)
desVar("pvt8" 0)
desVar("pvt9" 0)
desVar("pvt10" 0)
desVar("pvt11" 0)
desVar("pvt12" 0)
desVar("pvt13" 0)
desVar("pvtn0" 1)
desVar("pvtn1" 0)
desVar("pvtn2" 1)
desVar("pvtn3" 1)
desVar("pvtn4" 1)
desVar("pvtn5" 1)
desVar("pvtn6" 1)
desVar("pvtn7" 0)
desVar("pvtn8" 0)
desVar("pvtn9" 0)
desVar("pvtn10" 0)
desVar("pvtn11" 0)
desVar("pvtn12" 0)
desVar("pvtn13" 0)
run()
selectResults('tran)
pup_val = average((clip((v("/vdd" ?result "tran") - v("/outn" ?result "tran")) 2e-07 2.5e-07) / clip(i("/xdrv_p/out" ?result "tran") 2e-07 2.5e-07)))
pdn_val = (average((clip(v("/outp" ?result "tran") 2e-07 2.5e-07) / clip(i("/xdrv_p/out" ?result "tran") 2e-07 2.5e-07))) * -1)
fprintf(out_file "SF_ssres,SF,ss_res_bip_dio_disres,0.93,118.0,288010180,250,125,123,125,%f,%f,51.702,51.392\n" pup_val pdn_val)
drain(out_file)
printf("Result -> pup=%f, pdn=%f (Excel: pup=51.702, pdn=51.392)\n" pup_val pdn_val)

; --- Sim 8/9: SF (ss_res_bip_dio_disres), Vreg=0.95V, Temp=-13.0C, pvtp=122, pvtn=30 ---
printf("\n>>> [BAD] Running SF_ssres Sim 8/9: V=0.95V, T=-13.0C, pvtp=122, pvtn=30 <<<\n")
desVar("tem" -13.0)
desVar("vreg" 0.95)
temp(-13.0)
desVar("pvt0" 0)
desVar("pvt1" 1)
desVar("pvt2" 0)
desVar("pvt3" 1)
desVar("pvt4" 1)
desVar("pvt5" 1)
desVar("pvt6" 1)
desVar("pvt7" 0)
desVar("pvt8" 0)
desVar("pvt9" 0)
desVar("pvt10" 0)
desVar("pvt11" 0)
desVar("pvt12" 0)
desVar("pvt13" 0)
desVar("pvtn0" 0)
desVar("pvtn1" 1)
desVar("pvtn2" 1)
desVar("pvtn3" 1)
desVar("pvtn4" 1)
desVar("pvtn5" 0)
desVar("pvtn6" 0)
desVar("pvtn7" 0)
desVar("pvtn8" 0)
desVar("pvtn9" 0)
desVar("pvtn10" 0)
desVar("pvtn11" 0)
desVar("pvtn12" 0)
desVar("pvtn13" 0)
run()
selectResults('tran)
pup_val = average((clip((v("/vdd" ?result "tran") - v("/outn" ?result "tran")) 2e-07 2.5e-07) / clip(i("/xdrv_p/out" ?result "tran") 2e-07 2.5e-07)))
pdn_val = (average((clip(v("/outp" ?result "tran") 2e-07 2.5e-07) / clip(i("/xdrv_p/out" ?result "tran") 2e-07 2.5e-07))) * -1)
fprintf(out_file "SF_ssres,SF,ss_res_bip_dio_disres,0.95,-13.0,335002930,122,30,122,124,%f,%f,49.59,48.97\n" pup_val pdn_val)
drain(out_file)
printf("Result -> pup=%f, pdn=%f (Excel: pup=49.59, pdn=48.97)\n" pup_val pdn_val)

; --- Sim 9/9: SF (ss_res_bip_dio_disres), Vreg=0.97V, Temp=1.5C, pvtp=122, pvtn=243 ---
printf("\n>>> [BAD] Running SF_ssres Sim 9/9: V=0.97V, T=1.5C, pvtp=122, pvtn=243 <<<\n")
desVar("tem" 1.5)
desVar("vreg" 0.97)
temp(1.5)
desVar("pvt0" 0)
desVar("pvt1" 1)
desVar("pvt2" 0)
desVar("pvt3" 1)
desVar("pvt4" 1)
desVar("pvt5" 1)
desVar("pvt6" 1)
desVar("pvt7" 0)
desVar("pvt8" 0)
desVar("pvt9" 0)
desVar("pvt10" 0)
desVar("pvt11" 0)
desVar("pvt12" 0)
desVar("pvt13" 0)
desVar("pvtn0" 1)
desVar("pvtn1" 1)
desVar("pvtn2" 0)
desVar("pvtn3" 0)
desVar("pvtn4" 1)
desVar("pvtn5" 1)
desVar("pvtn6" 1)
desVar("pvtn7" 1)
desVar("pvtn8" 0)
desVar("pvtn9" 0)
desVar("pvtn10" 0)
desVar("pvtn11" 0)
desVar("pvtn12" 0)
desVar("pvtn13" 0)
run()
selectResults('tran)
pup_val = average((clip((v("/vdd" ?result "tran") - v("/outn" ?result "tran")) 2e-07 2.5e-07) / clip(i("/xdrv_p/out" ?result "tran") 2e-07 2.5e-07)))
pdn_val = (average((clip(v("/outp" ?result "tran") 2e-07 2.5e-07) / clip(i("/xdrv_p/out" ?result "tran") 2e-07 2.5e-07))) * -1)
fprintf(out_file "SF_ssres,SF,ss_res_bip_dio_disres,0.97,1.5,341103800,122,243,122,123,%f,%f,49.81,50.17\n" pup_val pdn_val)
drain(out_file)
printf("Result -> pup=%f, pdn=%f (Excel: pup=49.81, pdn=50.17)\n" pup_val pdn_val)

close(out_file)
printf("\n=== BAD SF_ssres Complete! Results in results_bad_SF_ssres.csv ===\n")
exit()
