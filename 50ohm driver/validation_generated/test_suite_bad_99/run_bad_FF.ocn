; -----------------------------------------------------------------------------
; Cadence Spectre OCEAN Script: BAD - FF
; PDK Model: TSMC 28nm 1.8V (crn28hpcp_1d8_elk...)
; MOS Section: ffmacro_mos_moscap | Resistor Section: ff_res_bip_dio_disres
; -----------------------------------------------------------------------------
simulator('spectre)
design("tsmc28_tx_tb" "tx_drv_ML" "schematic_seriliazer_top")
resultsDir("./ocean_bad_FF")

modelFile(
    '("/data/cad/pdk_all/pdk_tsmc/pdk_tsmc_28/PDK/TSMC_new_iPDK/models/spectre/crn28hpcp_1d8_elk_v1d0_2p2_shrink0d9_embedded_usage.scs" "ffmacro_mos_moscap")
    '("/data/cad/pdk_all/pdk_tsmc/pdk_tsmc_28/PDK/TSMC_new_iPDK/models/spectre/crn28hpcp_1d8_elk_v1d0_2p2_shrink0d9_embedded_usage.scs" "ff_res_bip_dio_disres")
    '("/data/cad/pdk_all/pdk_tsmc/pdk_tsmc_28/PDK/TSMC_new_iPDK/models/spectre/crn28hpcp_1d8_elk_v1d0_2p2_shrink0d9_embedded_usage.scs" "pre_simu")
)
analysis('dc ?saveOppoint t)
analysis('tran ?stop "275n")

envOption('termDirectionMismatch "ignore" 'termMismatch "ignore")
saveOption( ?infoOptions list(list("modelParameter" "models" "rawfile" "" "" "" t) list("element" "inst" "rawfile" "" "" "" t) list("outputParameter" "output" "rawfile" "" "" "" t) list("designParamVals" "parameters" "rawfile" "" "" "" t) list("primitives" "primitives" "rawfile" "" "" "" t) list("subckts" "subckts" "rawfile" "" "" "" t) list("asserts" "assert" "rawfile" "" "" "" nil) list("extremeinfo" "all" "logfile" "" "yes" "" nil) list("allcap" "allcap" "file" "" "" "" nil) list("<Click_To_Add>" "none" "rawfile" "" "" "" nil) ) )
save('i "/xdrv_p/out")

out_file = outfile("results_bad_FF.csv")
fprintf(out_file "suite,corner,res_sec,vreg,temp,pmon,pvtp_sim,pvtn_sim,gt_pvtp,gt_pvtn,sim_pup,sim_pdn,excel_pup,excel_pdn\n")
drain(out_file)

; --- Sim 1/21: FF (ff_res_bip_dio_disres), Vreg=0.81V, Temp=-23.0C, pvtp=14, pvtn=13 ---
printf("\n>>> [BAD] Running FF Sim 1/21: V=0.81V, T=-23.0C, pvtp=14, pvtn=13 <<<\n")
desVar("tem" -23.0)
desVar("vreg" 0.81)
temp(-23.0)
desVar("pvt0" 0)
desVar("pvt1" 1)
desVar("pvt2" 1)
desVar("pvt3" 1)
desVar("pvt4" 0)
desVar("pvt5" 0)
desVar("pvt6" 0)
desVar("pvt7" 0)
desVar("pvt8" 0)
desVar("pvt9" 0)
desVar("pvt10" 0)
desVar("pvt11" 0)
desVar("pvt12" 0)
desVar("pvt13" 0)
desVar("pvtn0" 1)
desVar("pvtn1" 0)
desVar("pvtn2" 1)
desVar("pvtn3" 1)
desVar("pvtn4" 0)
desVar("pvtn5" 0)
desVar("pvtn6" 0)
desVar("pvtn7" 0)
desVar("pvtn8" 0)
desVar("pvtn9" 0)
desVar("pvtn10" 0)
desVar("pvtn11" 0)
desVar("pvtn12" 0)
desVar("pvtn13" 0)
run()
selectResults('tran)
pup_val = average((clip((v("/vdd" ?result "tran") - v("/outn" ?result "tran")) 2e-07 2.5e-07) / clip(i("/xdrv_p/out" ?result "tran") 2e-07 2.5e-07)))
pdn_val = (average((clip(v("/outp" ?result "tran") 2e-07 2.5e-07) / clip(i("/xdrv_p/out" ?result "tran") 2e-07 2.5e-07))) * -1)
fprintf(out_file "FF,FF,ff_res_bip_dio_disres,0.81,-23.0,286120440,14,13,13,13,%f,%f,50.69,50.73\n" pup_val pdn_val)
drain(out_file)
printf("Result -> pup=%f, pdn=%f (Excel: pup=50.69, pdn=50.73)\n" pup_val pdn_val)

; --- Sim 2/21: FF (ff_res_bip_dio_disres), Vreg=0.81V, Temp=-22.5C, pvtp=14, pvtn=13 ---
printf("\n>>> [BAD] Running FF Sim 2/21: V=0.81V, T=-22.5C, pvtp=14, pvtn=13 <<<\n")
desVar("tem" -22.5)
desVar("vreg" 0.81)
temp(-22.5)
desVar("pvt0" 0)
desVar("pvt1" 1)
desVar("pvt2" 1)
desVar("pvt3" 1)
desVar("pvt4" 0)
desVar("pvt5" 0)
desVar("pvt6" 0)
desVar("pvt7" 0)
desVar("pvt8" 0)
desVar("pvt9" 0)
desVar("pvt10" 0)
desVar("pvt11" 0)
desVar("pvt12" 0)
desVar("pvt13" 0)
desVar("pvtn0" 1)
desVar("pvtn1" 0)
desVar("pvtn2" 1)
desVar("pvtn3" 1)
desVar("pvtn4" 0)
desVar("pvtn5" 0)
desVar("pvtn6" 0)
desVar("pvtn7" 0)
desVar("pvtn8" 0)
desVar("pvtn9" 0)
desVar("pvtn10" 0)
desVar("pvtn11" 0)
desVar("pvtn12" 0)
desVar("pvtn13" 0)
run()
selectResults('tran)
pup_val = average((clip((v("/vdd" ?result "tran") - v("/outn" ?result "tran")) 2e-07 2.5e-07) / clip(i("/xdrv_p/out" ?result "tran") 2e-07 2.5e-07)))
pdn_val = (average((clip(v("/outp" ?result "tran") 2e-07 2.5e-07) / clip(i("/xdrv_p/out" ?result "tran") 2e-07 2.5e-07))) * -1)
fprintf(out_file "FF,FF,ff_res_bip_dio_disres,0.81,-22.5,286024720,14,13,13,13,%f,%f,50.7,50.74\n" pup_val pdn_val)
drain(out_file)
printf("Result -> pup=%f, pdn=%f (Excel: pup=50.7, pdn=50.74)\n" pup_val pdn_val)

; --- Sim 3/21: FF (ff_res_bip_dio_disres), Vreg=0.83V, Temp=-15.5C, pvtp=13, pvtn=14 ---
printf("\n>>> [BAD] Running FF Sim 3/21: V=0.83V, T=-15.5C, pvtp=13, pvtn=14 <<<\n")
desVar("tem" -15.5)
desVar("vreg" 0.83)
temp(-15.5)
desVar("pvt0" 1)
desVar("pvt1" 0)
desVar("pvt2" 1)
desVar("pvt3" 1)
desVar("pvt4" 0)
desVar("pvt5" 0)
desVar("pvt6" 0)
desVar("pvt7" 0)
desVar("pvt8" 0)
desVar("pvt9" 0)
desVar("pvt10" 0)
desVar("pvt11" 0)
desVar("pvt12" 0)
desVar("pvt13" 0)
desVar("pvtn0" 0)
desVar("pvtn1" 1)
desVar("pvtn2" 1)
desVar("pvtn3" 1)
desVar("pvtn4" 0)
desVar("pvtn5" 0)
desVar("pvtn6" 0)
desVar("pvtn7" 0)
desVar("pvtn8" 0)
desVar("pvtn9" 0)
desVar("pvtn10" 0)
desVar("pvtn11" 0)
desVar("pvtn12" 0)
desVar("pvtn13" 0)
run()
selectResults('tran)
pup_val = average((clip((v("/vdd" ?result "tran") - v("/outn" ?result "tran")) 2e-07 2.5e-07) / clip(i("/xdrv_p/out" ?result "tran") 2e-07 2.5e-07)))
pdn_val = (average((clip(v("/outp" ?result "tran") 2e-07 2.5e-07) / clip(i("/xdrv_p/out" ?result "tran") 2e-07 2.5e-07))) * -1)
fprintf(out_file "FF,FF,ff_res_bip_dio_disres,0.83,-15.5,300582330,13,14,13,13,%f,%f,50.64,50.7\n" pup_val pdn_val)
drain(out_file)
printf("Result -> pup=%f, pdn=%f (Excel: pup=50.64, pdn=50.7)\n" pup_val pdn_val)

; --- Sim 4/21: FF (ff_res_bip_dio_disres), Vreg=0.83V, Temp=75.0C, pvtp=15, pvtn=15 ---
printf("\n>>> [BAD] Running FF Sim 4/21: V=0.83V, T=75.0C, pvtp=15, pvtn=15 <<<\n")
desVar("tem" 75.0)
desVar("vreg" 0.83)
temp(75.0)
desVar("pvt0" 1)
desVar("pvt1" 1)
desVar("pvt2" 1)
desVar("pvt3" 1)
desVar("pvt4" 0)
desVar("pvt5" 0)
desVar("pvt6" 0)
desVar("pvt7" 0)
desVar("pvt8" 0)
desVar("pvt9" 0)
desVar("pvt10" 0)
desVar("pvt11" 0)
desVar("pvt12" 0)
desVar("pvt13" 0)
desVar("pvtn0" 1)
desVar("pvtn1" 1)
desVar("pvtn2" 1)
desVar("pvtn3" 1)
desVar("pvtn4" 0)
desVar("pvtn5" 0)
desVar("pvtn6" 0)
desVar("pvtn7" 0)
desVar("pvtn8" 0)
desVar("pvtn9" 0)
desVar("pvtn10" 0)
desVar("pvtn11" 0)
desVar("pvtn12" 0)
desVar("pvtn13" 0)
run()
selectResults('tran)
pup_val = average((clip((v("/vdd" ?result "tran") - v("/outn" ?result "tran")) 2e-07 2.5e-07) / clip(i("/xdrv_p/out" ?result "tran") 2e-07 2.5e-07)))
pdn_val = (average((clip(v("/outp" ?result "tran") 2e-07 2.5e-07) / clip(i("/xdrv_p/out" ?result "tran") 2e-07 2.5e-07))) * -1)
fprintf(out_file "FF,FF,ff_res_bip_dio_disres,0.83,75.0,284657400,15,15,28,15,%f,%f,49.38,49.79\n" pup_val pdn_val)
drain(out_file)
printf("Result -> pup=%f, pdn=%f (Excel: pup=49.38, pdn=49.79)\n" pup_val pdn_val)

; --- Sim 5/21: FF (ff_res_bip_dio_disres), Vreg=0.83V, Temp=103.5C, pvtp=28, pvtn=15 ---
printf("\n>>> [BAD] Running FF Sim 5/21: V=0.83V, T=103.5C, pvtp=28, pvtn=15 <<<\n")
desVar("tem" 103.5)
desVar("vreg" 0.83)
temp(103.5)
desVar("pvt0" 0)
desVar("pvt1" 0)
desVar("pvt2" 1)
desVar("pvt3" 1)
desVar("pvt4" 1)
desVar("pvt5" 0)
desVar("pvt6" 0)
desVar("pvt7" 0)
desVar("pvt8" 0)
desVar("pvt9" 0)
desVar("pvt10" 0)
desVar("pvt11" 0)
desVar("pvt12" 0)
desVar("pvt13" 0)
desVar("pvtn0" 1)
desVar("pvtn1" 1)
desVar("pvtn2" 1)
desVar("pvtn3" 1)
desVar("pvtn4" 0)
desVar("pvtn5" 0)
desVar("pvtn6" 0)
desVar("pvtn7" 0)
desVar("pvtn8" 0)
desVar("pvtn9" 0)
desVar("pvtn10" 0)
desVar("pvtn11" 0)
desVar("pvtn12" 0)
desVar("pvtn13" 0)
run()
selectResults('tran)
pup_val = average((clip((v("/vdd" ?result "tran") - v("/outn" ?result "tran")) 2e-07 2.5e-07) / clip(i("/xdrv_p/out" ?result "tran") 2e-07 2.5e-07)))
pdn_val = (average((clip(v("/outp" ?result "tran") 2e-07 2.5e-07) / clip(i("/xdrv_p/out" ?result "tran") 2e-07 2.5e-07))) * -1)
fprintf(out_file "FF,FF,ff_res_bip_dio_disres,0.83,103.5,281757080,28,15,29,15,%f,%f,49.34,50.4\n" pup_val pdn_val)
drain(out_file)
printf("Result -> pup=%f, pdn=%f (Excel: pup=49.34, pdn=50.4)\n" pup_val pdn_val)

; --- Sim 6/21: FF (ff_res_bip_dio_disres), Vreg=0.85V, Temp=43.0C, pvtp=15, pvtn=14 ---
printf("\n>>> [BAD] Running FF Sim 6/21: V=0.85V, T=43.0C, pvtp=15, pvtn=14 <<<\n")
desVar("tem" 43.0)
desVar("vreg" 0.85)
temp(43.0)
desVar("pvt0" 1)
desVar("pvt1" 1)
desVar("pvt2" 1)
desVar("pvt3" 1)
desVar("pvt4" 0)
desVar("pvt5" 0)
desVar("pvt6" 0)
desVar("pvt7" 0)
desVar("pvt8" 0)
desVar("pvt9" 0)
desVar("pvt10" 0)
desVar("pvt11" 0)
desVar("pvt12" 0)
desVar("pvt13" 0)
desVar("pvtn0" 0)
desVar("pvtn1" 1)
desVar("pvtn2" 1)
desVar("pvtn3" 1)
desVar("pvtn4" 0)
desVar("pvtn5" 0)
desVar("pvtn6" 0)
desVar("pvtn7" 0)
desVar("pvtn8" 0)
desVar("pvtn9" 0)
desVar("pvtn10" 0)
desVar("pvtn11" 0)
desVar("pvtn12" 0)
desVar("pvtn13" 0)
run()
selectResults('tran)
pup_val = average((clip((v("/vdd" ?result "tran") - v("/outn" ?result "tran")) 2e-07 2.5e-07) / clip(i("/xdrv_p/out" ?result "tran") 2e-07 2.5e-07)))
pdn_val = (average((clip(v("/outp" ?result "tran") 2e-07 2.5e-07) / clip(i("/xdrv_p/out" ?result "tran") 2e-07 2.5e-07))) * -1)
fprintf(out_file "FF,FF,ff_res_bip_dio_disres,0.85,43.0,302035570,15,14,14,14,%f,%f,50.7,50.26\n" pup_val pdn_val)
drain(out_file)
printf("Result -> pup=%f, pdn=%f (Excel: pup=50.7, pdn=50.26)\n" pup_val pdn_val)

; --- Sim 7/21: FF (ff_res_bip_dio_disres), Vreg=0.85V, Temp=62.0C, pvtp=15, pvtn=15 ---
printf("\n>>> [BAD] Running FF Sim 7/21: V=0.85V, T=62.0C, pvtp=15, pvtn=15 <<<\n")
desVar("tem" 62.0)
desVar("vreg" 0.85)
temp(62.0)
desVar("pvt0" 1)
desVar("pvt1" 1)
desVar("pvt2" 1)
desVar("pvt3" 1)
desVar("pvt4" 0)
desVar("pvt5" 0)
desVar("pvt6" 0)
desVar("pvt7" 0)
desVar("pvt8" 0)
desVar("pvt9" 0)
desVar("pvt10" 0)
desVar("pvt11" 0)
desVar("pvt12" 0)
desVar("pvt13" 0)
desVar("pvtn0" 1)
desVar("pvtn1" 1)
desVar("pvtn2" 1)
desVar("pvtn3" 1)
desVar("pvtn4" 0)
desVar("pvtn5" 0)
desVar("pvtn6" 0)
desVar("pvtn7" 0)
desVar("pvtn8" 0)
desVar("pvtn9" 0)
desVar("pvtn10" 0)
desVar("pvtn11" 0)
desVar("pvtn12" 0)
desVar("pvtn13" 0)
run()
selectResults('tran)
pup_val = average((clip((v("/vdd" ?result "tran") - v("/outn" ?result "tran")) 2e-07 2.5e-07) / clip(i("/xdrv_p/out" ?result "tran") 2e-07 2.5e-07)))
pdn_val = (average((clip(v("/outp" ?result "tran") 2e-07 2.5e-07) / clip(i("/xdrv_p/out" ?result "tran") 2e-07 2.5e-07))) * -1)
fprintf(out_file "FF,FF,ff_res_bip_dio_disres,0.85,62.0,298650990,15,15,15,14,%f,%f,49.96,50.69\n" pup_val pdn_val)
drain(out_file)
printf("Result -> pup=%f, pdn=%f (Excel: pup=49.96, pdn=50.69)\n" pup_val pdn_val)

; --- Sim 8/21: FF (ff_res_bip_dio_disres), Vreg=0.85V, Temp=108.0C, pvtp=28, pvtn=15 ---
printf("\n>>> [BAD] Running FF Sim 8/21: V=0.85V, T=108.0C, pvtp=28, pvtn=15 <<<\n")
desVar("tem" 108.0)
desVar("vreg" 0.85)
temp(108.0)
desVar("pvt0" 0)
desVar("pvt1" 0)
desVar("pvt2" 1)
desVar("pvt3" 1)
desVar("pvt4" 1)
desVar("pvt5" 0)
desVar("pvt6" 0)
desVar("pvt7" 0)
desVar("pvt8" 0)
desVar("pvt9" 0)
desVar("pvt10" 0)
desVar("pvt11" 0)
desVar("pvt12" 0)
desVar("pvt13" 0)
desVar("pvtn0" 1)
desVar("pvtn1" 1)
desVar("pvtn2" 1)
desVar("pvtn3" 1)
desVar("pvtn4" 0)
desVar("pvtn5" 0)
desVar("pvtn6" 0)
desVar("pvtn7" 0)
desVar("pvtn8" 0)
desVar("pvtn9" 0)
desVar("pvtn10" 0)
desVar("pvtn11" 0)
desVar("pvtn12" 0)
desVar("pvtn13" 0)
run()
selectResults('tran)
pup_val = average((clip((v("/vdd" ?result "tran") - v("/outn" ?result "tran")) 2e-07 2.5e-07) / clip(i("/xdrv_p/out" ?result "tran") 2e-07 2.5e-07)))
pdn_val = (average((clip(v("/outp" ?result "tran") 2e-07 2.5e-07) / clip(i("/xdrv_p/out" ?result "tran") 2e-07 2.5e-07))) * -1)
fprintf(out_file "FF,FF,ff_res_bip_dio_disres,0.85,108.0,292321120,28,15,29,15,%f,%f,49.34,50.32\n" pup_val pdn_val)
drain(out_file)
printf("Result -> pup=%f, pdn=%f (Excel: pup=49.34, pdn=50.32)\n" pup_val pdn_val)

; --- Sim 9/21: FF (ff_res_bip_dio_disres), Vreg=0.87V, Temp=49.0C, pvtp=15, pvtn=14 ---
printf("\n>>> [BAD] Running FF Sim 9/21: V=0.87V, T=49.0C, pvtp=15, pvtn=14 <<<\n")
desVar("tem" 49.0)
desVar("vreg" 0.87)
temp(49.0)
desVar("pvt0" 1)
desVar("pvt1" 1)
desVar("pvt2" 1)
desVar("pvt3" 1)
desVar("pvt4" 0)
desVar("pvt5" 0)
desVar("pvt6" 0)
desVar("pvt7" 0)
desVar("pvt8" 0)
desVar("pvt9" 0)
desVar("pvt10" 0)
desVar("pvt11" 0)
desVar("pvt12" 0)
desVar("pvt13" 0)
desVar("pvtn0" 0)
desVar("pvtn1" 1)
desVar("pvtn2" 1)
desVar("pvtn3" 1)
desVar("pvtn4" 0)
desVar("pvtn5" 0)
desVar("pvtn6" 0)
desVar("pvtn7" 0)
desVar("pvtn8" 0)
desVar("pvtn9" 0)
desVar("pvtn10" 0)
desVar("pvtn11" 0)
desVar("pvtn12" 0)
desVar("pvtn13" 0)
run()
selectResults('tran)
pup_val = average((clip((v("/vdd" ?result "tran") - v("/outn" ?result "tran")) 2e-07 2.5e-07) / clip(i("/xdrv_p/out" ?result "tran") 2e-07 2.5e-07)))
pdn_val = (average((clip(v("/outp" ?result "tran") 2e-07 2.5e-07) / clip(i("/xdrv_p/out" ?result "tran") 2e-07 2.5e-07))) * -1)
fprintf(out_file "FF,FF,ff_res_bip_dio_disres,0.87,49.0,313587120,15,14,14,14,%f,%f,50.69,50.22\n" pup_val pdn_val)
drain(out_file)
printf("Result -> pup=%f, pdn=%f (Excel: pup=50.69, pdn=50.22)\n" pup_val pdn_val)

; --- Sim 10/21: FF (ff_res_bip_dio_disres), Vreg=0.87V, Temp=70.0C, pvtp=15, pvtn=15 ---
printf("\n>>> [BAD] Running FF Sim 10/21: V=0.87V, T=70.0C, pvtp=15, pvtn=15 <<<\n")
desVar("tem" 70.0)
desVar("vreg" 0.87)
temp(70.0)
desVar("pvt0" 1)
desVar("pvt1" 1)
desVar("pvt2" 1)
desVar("pvt3" 1)
desVar("pvt4" 0)
desVar("pvt5" 0)
desVar("pvt6" 0)
desVar("pvt7" 0)
desVar("pvt8" 0)
desVar("pvt9" 0)
desVar("pvt10" 0)
desVar("pvt11" 0)
desVar("pvt12" 0)
desVar("pvt13" 0)
desVar("pvtn0" 1)
desVar("pvtn1" 1)
desVar("pvtn2" 1)
desVar("pvtn3" 1)
desVar("pvtn4" 0)
desVar("pvtn5" 0)
desVar("pvtn6" 0)
desVar("pvtn7" 0)
desVar("pvtn8" 0)
desVar("pvtn9" 0)
desVar("pvtn10" 0)
desVar("pvtn11" 0)
desVar("pvtn12" 0)
desVar("pvtn13" 0)
run()
selectResults('tran)
pup_val = average((clip((v("/vdd" ?result "tran") - v("/outn" ?result "tran")) 2e-07 2.5e-07) / clip(i("/xdrv_p/out" ?result "tran") 2e-07 2.5e-07)))
pdn_val = (average((clip(v("/outp" ?result "tran") 2e-07 2.5e-07) / clip(i("/xdrv_p/out" ?result "tran") 2e-07 2.5e-07))) * -1)
fprintf(out_file "FF,FF,ff_res_bip_dio_disres,0.87,70.0,309310040,15,15,15,14,%f,%f,50.07,50.7\n" pup_val pdn_val)
drain(out_file)
printf("Result -> pup=%f, pdn=%f (Excel: pup=50.07, pdn=50.7)\n" pup_val pdn_val)

; --- Sim 11/21: FF (ff_res_bip_dio_disres), Vreg=0.87V, Temp=84.5C, pvtp=28, pvtn=15 ---
printf("\n>>> [BAD] Running FF Sim 11/21: V=0.87V, T=84.5C, pvtp=28, pvtn=15 <<<\n")
desVar("tem" 84.5)
desVar("vreg" 0.87)
temp(84.5)
desVar("pvt0" 0)
desVar("pvt1" 0)
desVar("pvt2" 1)
desVar("pvt3" 1)
desVar("pvt4" 1)
desVar("pvt5" 0)
desVar("pvt6" 0)
desVar("pvt7" 0)
desVar("pvt8" 0)
desVar("pvt9" 0)
desVar("pvt10" 0)
desVar("pvt11" 0)
desVar("pvt12" 0)
desVar("pvt13" 0)
desVar("pvtn0" 1)
desVar("pvtn1" 1)
desVar("pvtn2" 1)
desVar("pvtn3" 1)
desVar("pvtn4" 0)
desVar("pvtn5" 0)
desVar("pvtn6" 0)
desVar("pvtn7" 0)
desVar("pvtn8" 0)
desVar("pvtn9" 0)
desVar("pvtn10" 0)
desVar("pvtn11" 0)
desVar("pvtn12" 0)
desVar("pvtn13" 0)
run()
selectResults('tran)
pup_val = average((clip((v("/vdd" ?result "tran") - v("/outn" ?result "tran")) 2e-07 2.5e-07) / clip(i("/xdrv_p/out" ?result "tran") 2e-07 2.5e-07)))
pdn_val = (average((clip(v("/outp" ?result "tran") 2e-07 2.5e-07) / clip(i("/xdrv_p/out" ?result "tran") 2e-07 2.5e-07))) * -1)
fprintf(out_file "FF,FF,ff_res_bip_dio_disres,0.87,84.5,306707620,28,15,15,15,%f,%f,50.7,49.64\n" pup_val pdn_val)
drain(out_file)
printf("Result -> pup=%f, pdn=%f (Excel: pup=50.7, pdn=49.64)\n" pup_val pdn_val)

; --- Sim 12/21: FF (ff_res_bip_dio_disres), Vreg=0.87V, Temp=111.0C, pvtp=29, pvtn=15 ---
printf("\n>>> [BAD] Running FF Sim 12/21: V=0.87V, T=111.0C, pvtp=29, pvtn=15 <<<\n")
desVar("tem" 111.0)
desVar("vreg" 0.87)
temp(111.0)
desVar("pvt0" 1)
desVar("pvt1" 0)
desVar("pvt2" 1)
desVar("pvt3" 1)
desVar("pvt4" 1)
desVar("pvt5" 0)
desVar("pvt6" 0)
desVar("pvt7" 0)
desVar("pvt8" 0)
desVar("pvt9" 0)
desVar("pvt10" 0)
desVar("pvt11" 0)
desVar("pvt12" 0)
desVar("pvt13" 0)
desVar("pvtn0" 1)
desVar("pvtn1" 1)
desVar("pvtn2" 1)
desVar("pvtn3" 1)
desVar("pvtn4" 0)
desVar("pvtn5" 0)
desVar("pvtn6" 0)
desVar("pvtn7" 0)
desVar("pvtn8" 0)
desVar("pvtn9" 0)
desVar("pvtn10" 0)
desVar("pvtn11" 0)
desVar("pvtn12" 0)
desVar("pvtn13" 0)
run()
selectResults('tran)
pup_val = average((clip((v("/vdd" ?result "tran") - v("/outn" ?result "tran")) 2e-07 2.5e-07) / clip(i("/xdrv_p/out" ?result "tran") 2e-07 2.5e-07)))
pdn_val = (average((clip(v("/outp" ?result "tran") 2e-07 2.5e-07) / clip(i("/xdrv_p/out" ?result "tran") 2e-07 2.5e-07))) * -1)
fprintf(out_file "FF,FF,ff_res_bip_dio_disres,0.87,111.0,302553350,29,15,28,15,%f,%f,50.68,50.21\n" pup_val pdn_val)
drain(out_file)
printf("Result -> pup=%f, pdn=%f (Excel: pup=50.68, pdn=50.21)\n" pup_val pdn_val)

; --- Sim 13/21: FF (ff_res_bip_dio_disres), Vreg=0.89V, Temp=7.5C, pvtp=13, pvtn=13 ---
printf("\n>>> [BAD] Running FF Sim 13/21: V=0.89V, T=7.5C, pvtp=13, pvtn=13 <<<\n")
desVar("tem" 7.5)
desVar("vreg" 0.89)
temp(7.5)
desVar("pvt0" 1)
desVar("pvt1" 0)
desVar("pvt2" 1)
desVar("pvt3" 1)
desVar("pvt4" 0)
desVar("pvt5" 0)
desVar("pvt6" 0)
desVar("pvt7" 0)
desVar("pvt8" 0)
desVar("pvt9" 0)
desVar("pvt10" 0)
desVar("pvt11" 0)
desVar("pvt12" 0)
desVar("pvt13" 0)
desVar("pvtn0" 1)
desVar("pvtn1" 0)
desVar("pvtn2" 1)
desVar("pvtn3" 1)
desVar("pvtn4" 0)
desVar("pvtn5" 0)
desVar("pvtn6" 0)
desVar("pvtn7" 0)
desVar("pvtn8" 0)
desVar("pvtn9" 0)
desVar("pvtn10" 0)
desVar("pvtn11" 0)
desVar("pvtn12" 0)
desVar("pvtn13" 0)
run()
selectResults('tran)
pup_val = average((clip((v("/vdd" ?result "tran") - v("/outn" ?result "tran")) 2e-07 2.5e-07) / clip(i("/xdrv_p/out" ?result "tran") 2e-07 2.5e-07)))
pdn_val = (average((clip(v("/outp" ?result "tran") 2e-07 2.5e-07) / clip(i("/xdrv_p/out" ?result "tran") 2e-07 2.5e-07))) * -1)
fprintf(out_file "FF,FF,ff_res_bip_dio_disres,0.89,7.5,338388420,13,13,13,14,%f,%f,50.66,49.12\n" pup_val pdn_val)
drain(out_file)
printf("Result -> pup=%f, pdn=%f (Excel: pup=50.66, pdn=49.12)\n" pup_val pdn_val)

; --- Sim 14/21: FF (ff_res_bip_dio_disres), Vreg=0.89V, Temp=8.0C, pvtp=13, pvtn=13 ---
printf("\n>>> [BAD] Running FF Sim 14/21: V=0.89V, T=8.0C, pvtp=13, pvtn=13 <<<\n")
desVar("tem" 8.0)
desVar("vreg" 0.89)
temp(8.0)
desVar("pvt0" 1)
desVar("pvt1" 0)
desVar("pvt2" 1)
desVar("pvt3" 1)
desVar("pvt4" 0)
desVar("pvt5" 0)
desVar("pvt6" 0)
desVar("pvt7" 0)
desVar("pvt8" 0)
desVar("pvt9" 0)
desVar("pvt10" 0)
desVar("pvt11" 0)
desVar("pvt12" 0)
desVar("pvt13" 0)
desVar("pvtn0" 1)
desVar("pvtn1" 0)
desVar("pvtn2" 1)
desVar("pvtn3" 1)
desVar("pvtn4" 0)
desVar("pvtn5" 0)
desVar("pvtn6" 0)
desVar("pvtn7" 0)
desVar("pvtn8" 0)
desVar("pvtn9" 0)
desVar("pvtn10" 0)
desVar("pvtn11" 0)
desVar("pvtn12" 0)
desVar("pvtn13" 0)
run()
selectResults('tran)
pup_val = average((clip((v("/vdd" ?result "tran") - v("/outn" ?result "tran")) 2e-07 2.5e-07) / clip(i("/xdrv_p/out" ?result "tran") 2e-07 2.5e-07)))
pdn_val = (average((clip(v("/outp" ?result "tran") 2e-07 2.5e-07) / clip(i("/xdrv_p/out" ?result "tran") 2e-07 2.5e-07))) * -1)
fprintf(out_file "FF,FF,ff_res_bip_dio_disres,0.89,8.0,338236030,13,13,13,14,%f,%f,50.67,49.13\n" pup_val pdn_val)
drain(out_file)
printf("Result -> pup=%f, pdn=%f (Excel: pup=50.67, pdn=49.13)\n" pup_val pdn_val)

; --- Sim 15/21: FF (ff_res_bip_dio_disres), Vreg=0.91V, Temp=14.0C, pvtp=13, pvtn=14 ---
printf("\n>>> [BAD] Running FF Sim 15/21: V=0.91V, T=14.0C, pvtp=13, pvtn=14 <<<\n")
desVar("tem" 14.0)
desVar("vreg" 0.91)
temp(14.0)
desVar("pvt0" 1)
desVar("pvt1" 0)
desVar("pvt2" 1)
desVar("pvt3" 1)
desVar("pvt4" 0)
desVar("pvt5" 0)
desVar("pvt6" 0)
desVar("pvt7" 0)
desVar("pvt8" 0)
desVar("pvt9" 0)
desVar("pvt10" 0)
desVar("pvt11" 0)
desVar("pvt12" 0)
desVar("pvt13" 0)
desVar("pvtn0" 0)
desVar("pvtn1" 1)
desVar("pvtn2" 1)
desVar("pvtn3" 1)
desVar("pvtn4" 0)
desVar("pvtn5" 0)
desVar("pvtn6" 0)
desVar("pvtn7" 0)
desVar("pvtn8" 0)
desVar("pvtn9" 0)
desVar("pvtn10" 0)
desVar("pvtn11" 0)
desVar("pvtn12" 0)
desVar("pvtn13" 0)
run()
selectResults('tran)
pup_val = average((clip((v("/vdd" ?result "tran") - v("/outn" ?result "tran")) 2e-07 2.5e-07) / clip(i("/xdrv_p/out" ?result "tran") 2e-07 2.5e-07)))
pdn_val = (average((clip(v("/outp" ?result "tran") 2e-07 2.5e-07) / clip(i("/xdrv_p/out" ?result "tran") 2e-07 2.5e-07))) * -1)
fprintf(out_file "FF,FF,ff_res_bip_dio_disres,0.91,14.0,349731200,13,14,13,13,%f,%f,50.66,50.7\n" pup_val pdn_val)
drain(out_file)
printf("Result -> pup=%f, pdn=%f (Excel: pup=50.66, pdn=50.7)\n" pup_val pdn_val)

; --- Sim 16/21: FF (ff_res_bip_dio_disres), Vreg=0.93V, Temp=20.5C, pvtp=14, pvtn=13 ---
printf("\n>>> [BAD] Running FF Sim 16/21: V=0.93V, T=20.5C, pvtp=14, pvtn=13 <<<\n")
desVar("tem" 20.5)
desVar("vreg" 0.93)
temp(20.5)
desVar("pvt0" 0)
desVar("pvt1" 1)
desVar("pvt2" 1)
desVar("pvt3" 1)
desVar("pvt4" 0)
desVar("pvt5" 0)
desVar("pvt6" 0)
desVar("pvt7" 0)
desVar("pvt8" 0)
desVar("pvt9" 0)
desVar("pvt10" 0)
desVar("pvt11" 0)
desVar("pvt12" 0)
desVar("pvt13" 0)
desVar("pvtn0" 1)
desVar("pvtn1" 0)
desVar("pvtn2" 1)
desVar("pvtn3" 1)
desVar("pvtn4" 0)
desVar("pvtn5" 0)
desVar("pvtn6" 0)
desVar("pvtn7" 0)
desVar("pvtn8" 0)
desVar("pvtn9" 0)
desVar("pvtn10" 0)
desVar("pvtn11" 0)
desVar("pvtn12" 0)
desVar("pvtn13" 0)
run()
selectResults('tran)
pup_val = average((clip((v("/vdd" ?result "tran") - v("/outn" ?result "tran")) 2e-07 2.5e-07) / clip(i("/xdrv_p/out" ?result "tran") 2e-07 2.5e-07)))
pdn_val = (average((clip(v("/outp" ?result "tran") 2e-07 2.5e-07) / clip(i("/xdrv_p/out" ?result "tran") 2e-07 2.5e-07))) * -1)
fprintf(out_file "FF,FF,ff_res_bip_dio_disres,0.93,20.5,360400530,14,13,13,13,%f,%f,50.69,50.71\n" pup_val pdn_val)
drain(out_file)
printf("Result -> pup=%f, pdn=%f (Excel: pup=50.69, pdn=50.71)\n" pup_val pdn_val)

; --- Sim 17/21: FF (ff_res_bip_dio_disres), Vreg=0.93V, Temp=90.0C, pvtp=15, pvtn=14 ---
printf("\n>>> [BAD] Running FF Sim 17/21: V=0.93V, T=90.0C, pvtp=15, pvtn=14 <<<\n")
desVar("tem" 90.0)
desVar("vreg" 0.93)
temp(90.0)
desVar("pvt0" 1)
desVar("pvt1" 1)
desVar("pvt2" 1)
desVar("pvt3" 1)
desVar("pvt4" 0)
desVar("pvt5" 0)
desVar("pvt6" 0)
desVar("pvt7" 0)
desVar("pvt8" 0)
desVar("pvt9" 0)
desVar("pvt10" 0)
desVar("pvt11" 0)
desVar("pvt12" 0)
desVar("pvt13" 0)
desVar("pvtn0" 0)
desVar("pvtn1" 1)
desVar("pvtn2" 1)
desVar("pvtn3" 1)
desVar("pvtn4" 0)
desVar("pvtn5" 0)
desVar("pvtn6" 0)
desVar("pvtn7" 0)
desVar("pvtn8" 0)
desVar("pvtn9" 0)
desVar("pvtn10" 0)
desVar("pvtn11" 0)
desVar("pvtn12" 0)
desVar("pvtn13" 0)
run()
selectResults('tran)
pup_val = average((clip((v("/vdd" ?result "tran") - v("/outn" ?result "tran")) 2e-07 2.5e-07) / clip(i("/xdrv_p/out" ?result "tran") 2e-07 2.5e-07)))
pdn_val = (average((clip(v("/outp" ?result "tran") 2e-07 2.5e-07) / clip(i("/xdrv_p/out" ?result "tran") 2e-07 2.5e-07))) * -1)
fprintf(out_file "FF,FF,ff_res_bip_dio_disres,0.93,90.0,338336860,15,14,15,15,%f,%f,50.4,49.33\n" pup_val pdn_val)
drain(out_file)
printf("Result -> pup=%f, pdn=%f (Excel: pup=50.4, pdn=49.33)\n" pup_val pdn_val)

; --- Sim 18/21: FF (ff_res_bip_dio_disres), Vreg=0.95V, Temp=-36.5C, pvtp=12, pvtn=13 ---
printf("\n>>> [BAD] Running FF Sim 18/21: V=0.95V, T=-36.5C, pvtp=12, pvtn=13 <<<\n")
desVar("tem" -36.5)
desVar("vreg" 0.95)
temp(-36.5)
desVar("pvt0" 0)
desVar("pvt1" 0)
desVar("pvt2" 1)
desVar("pvt3" 1)
desVar("pvt4" 0)
desVar("pvt5" 0)
desVar("pvt6" 0)
desVar("pvt7" 0)
desVar("pvt8" 0)
desVar("pvt9" 0)
desVar("pvt10" 0)
desVar("pvt11" 0)
desVar("pvt12" 0)
desVar("pvt13" 0)
desVar("pvtn0" 1)
desVar("pvtn1" 0)
desVar("pvtn2" 1)
desVar("pvtn3" 1)
desVar("pvtn4" 0)
desVar("pvtn5" 0)
desVar("pvtn6" 0)
desVar("pvtn7" 0)
desVar("pvtn8" 0)
desVar("pvtn9" 0)
desVar("pvtn10" 0)
desVar("pvtn11" 0)
desVar("pvtn12" 0)
desVar("pvtn13" 0)
run()
selectResults('tran)
pup_val = average((clip((v("/vdd" ?result "tran") - v("/outn" ?result "tran")) 2e-07 2.5e-07) / clip(i("/xdrv_p/out" ?result "tran") 2e-07 2.5e-07)))
pdn_val = (average((clip(v("/outp" ?result "tran") 2e-07 2.5e-07) / clip(i("/xdrv_p/out" ?result "tran") 2e-07 2.5e-07))) * -1)
fprintf(out_file "FF,FF,ff_res_bip_dio_disres,0.95,-36.5,403420960,12,13,12,12,%f,%f,50.47,50.7\n" pup_val pdn_val)
drain(out_file)
printf("Result -> pup=%f, pdn=%f (Excel: pup=50.47, pdn=50.7)\n" pup_val pdn_val)

; --- Sim 19/21: FF (ff_res_bip_dio_disres), Vreg=0.97V, Temp=-22.5C, pvtp=12, pvtn=13 ---
printf("\n>>> [BAD] Running FF Sim 19/21: V=0.97V, T=-22.5C, pvtp=12, pvtn=13 <<<\n")
desVar("tem" -22.5)
desVar("vreg" 0.97)
temp(-22.5)
desVar("pvt0" 0)
desVar("pvt1" 0)
desVar("pvt2" 1)
desVar("pvt3" 1)
desVar("pvt4" 0)
desVar("pvt5" 0)
desVar("pvt6" 0)
desVar("pvt7" 0)
desVar("pvt8" 0)
desVar("pvt9" 0)
desVar("pvt10" 0)
desVar("pvt11" 0)
desVar("pvt12" 0)
desVar("pvt13" 0)
desVar("pvtn0" 1)
desVar("pvtn1" 0)
desVar("pvtn2" 1)
desVar("pvtn3" 1)
desVar("pvtn4" 0)
desVar("pvtn5" 0)
desVar("pvtn6" 0)
desVar("pvtn7" 0)
desVar("pvtn8" 0)
desVar("pvtn9" 0)
desVar("pvtn10" 0)
desVar("pvtn11" 0)
desVar("pvtn12" 0)
desVar("pvtn13" 0)
run()
selectResults('tran)
pup_val = average((clip((v("/vdd" ?result "tran") - v("/outn" ?result "tran")) 2e-07 2.5e-07) / clip(i("/xdrv_p/out" ?result "tran") 2e-07 2.5e-07)))
pdn_val = (average((clip(v("/outp" ?result "tran") 2e-07 2.5e-07) / clip(i("/xdrv_p/out" ?result "tran") 2e-07 2.5e-07))) * -1)
fprintf(out_file "FF,FF,ff_res_bip_dio_disres,0.97,-22.5,409057240,12,13,13,13,%f,%f,49.21,49.44\n" pup_val pdn_val)
drain(out_file)
printf("Result -> pup=%f, pdn=%f (Excel: pup=49.21, pdn=49.44)\n" pup_val pdn_val)

; --- Sim 20/21: FF (ff_res_bip_dio_disres), Vreg=0.97V, Temp=30.0C, pvtp=13, pvtn=13 ---
printf("\n>>> [BAD] Running FF Sim 20/21: V=0.97V, T=30.0C, pvtp=13, pvtn=13 <<<\n")
desVar("tem" 30.0)
desVar("vreg" 0.97)
temp(30.0)
desVar("pvt0" 1)
desVar("pvt1" 0)
desVar("pvt2" 1)
desVar("pvt3" 1)
desVar("pvt4" 0)
desVar("pvt5" 0)
desVar("pvt6" 0)
desVar("pvt7" 0)
desVar("pvt8" 0)
desVar("pvt9" 0)
desVar("pvt10" 0)
desVar("pvt11" 0)
desVar("pvt12" 0)
desVar("pvt13" 0)
desVar("pvtn0" 1)
desVar("pvtn1" 0)
desVar("pvtn2" 1)
desVar("pvtn3" 1)
desVar("pvtn4" 0)
desVar("pvtn5" 0)
desVar("pvtn6" 0)
desVar("pvtn7" 0)
desVar("pvtn8" 0)
desVar("pvtn9" 0)
desVar("pvtn10" 0)
desVar("pvtn11" 0)
desVar("pvtn12" 0)
desVar("pvtn13" 0)
run()
selectResults('tran)
pup_val = average((clip((v("/vdd" ?result "tran") - v("/outn" ?result "tran")) 2e-07 2.5e-07) / clip(i("/xdrv_p/out" ?result "tran") 2e-07 2.5e-07)))
pdn_val = (average((clip(v("/outp" ?result "tran") 2e-07 2.5e-07) / clip(i("/xdrv_p/out" ?result "tran") 2e-07 2.5e-07))) * -1)
fprintf(out_file "FF,FF,ff_res_bip_dio_disres,0.97,30.0,381106610,13,13,14,13,%f,%f,49.25,50.69\n" pup_val pdn_val)
drain(out_file)
printf("Result -> pup=%f, pdn=%f (Excel: pup=49.25, pdn=50.69)\n" pup_val pdn_val)

; --- Sim 21/21: FF (ff_res_bip_dio_disres), Vreg=0.99V, Temp=104.5C, pvtp=15, pvtn=14 ---
printf("\n>>> [BAD] Running FF Sim 21/21: V=0.99V, T=104.5C, pvtp=15, pvtn=14 <<<\n")
desVar("tem" 104.5)
desVar("vreg" 0.99)
temp(104.5)
desVar("pvt0" 1)
desVar("pvt1" 1)
desVar("pvt2" 1)
desVar("pvt3" 1)
desVar("pvt4" 0)
desVar("pvt5" 0)
desVar("pvt6" 0)
desVar("pvt7" 0)
desVar("pvt8" 0)
desVar("pvt9" 0)
desVar("pvt10" 0)
desVar("pvt11" 0)
desVar("pvt12" 0)
desVar("pvt13" 0)
desVar("pvtn0" 0)
desVar("pvtn1" 1)
desVar("pvtn2" 1)
desVar("pvtn3" 1)
desVar("pvtn4" 0)
desVar("pvtn5" 0)
desVar("pvtn6" 0)
desVar("pvtn7" 0)
desVar("pvtn8" 0)
desVar("pvtn9" 0)
desVar("pvtn10" 0)
desVar("pvtn11" 0)
desVar("pvtn12" 0)
desVar("pvtn13" 0)
run()
selectResults('tran)
pup_val = average((clip((v("/vdd" ?result "tran") - v("/outn" ?result "tran")) 2e-07 2.5e-07) / clip(i("/xdrv_p/out" ?result "tran") 2e-07 2.5e-07)))
pdn_val = (average((clip(v("/outp" ?result "tran") 2e-07 2.5e-07) / clip(i("/xdrv_p/out" ?result "tran") 2e-07 2.5e-07))) * -1)
fprintf(out_file "FF,FF,ff_res_bip_dio_disres,0.99,104.5,363980920,15,14,15,15,%f,%f,50.7,49.31\n" pup_val pdn_val)
drain(out_file)
printf("Result -> pup=%f, pdn=%f (Excel: pup=50.7, pdn=49.31)\n" pup_val pdn_val)

close(out_file)
printf("\n=== BAD FF Complete! Results in results_bad_FF.csv ===\n")
exit()
