; -----------------------------------------------------------------------------
; Cadence Spectre OCEAN Script: BAD - TT
; PDK Model: TSMC 28nm 1.8V (crn28hpcp_1d8_elk...)
; MOS Section: ttmacro_mos_moscap | Resistor Section: tt_res_bip_dio_disres
; -----------------------------------------------------------------------------
simulator('spectre)
design("tsmc28_tx_tb" "tx_drv_ML" "schematic_seriliazer_top")
resultsDir("./ocean_bad_TT")

modelFile(
    '("/data/cad/pdk_all/pdk_tsmc/pdk_tsmc_28/PDK/TSMC_new_iPDK/models/spectre/crn28hpcp_1d8_elk_v1d0_2p2_shrink0d9_embedded_usage.scs" "ttmacro_mos_moscap")
    '("/data/cad/pdk_all/pdk_tsmc/pdk_tsmc_28/PDK/TSMC_new_iPDK/models/spectre/crn28hpcp_1d8_elk_v1d0_2p2_shrink0d9_embedded_usage.scs" "tt_res_bip_dio_disres")
    '("/data/cad/pdk_all/pdk_tsmc/pdk_tsmc_28/PDK/TSMC_new_iPDK/models/spectre/crn28hpcp_1d8_elk_v1d0_2p2_shrink0d9_embedded_usage.scs" "pre_simu")
)
analysis('dc ?saveOppoint t)
analysis('tran ?stop "275n")

envOption('termDirectionMismatch "ignore" 'termMismatch "ignore")
saveOption( ?infoOptions list(list("modelParameter" "models" "rawfile" "" "" "" t) list("element" "inst" "rawfile" "" "" "" t) list("outputParameter" "output" "rawfile" "" "" "" t) list("designParamVals" "parameters" "rawfile" "" "" "" t) list("primitives" "primitives" "rawfile" "" "" "" t) list("subckts" "subckts" "rawfile" "" "" "" t) list("asserts" "assert" "rawfile" "" "" "" nil) list("extremeinfo" "all" "logfile" "" "yes" "" nil) list("allcap" "allcap" "file" "" "" "" nil) list("<Click_To_Add>" "none" "rawfile" "" "" "" nil) ) )
save('i "/xdrv_p/out")

out_file = outfile("results_bad_TT.csv")
fprintf(out_file "suite,corner,res_sec,vreg,temp,pmon,pvtp_sim,pvtn_sim,gt_pvtp,gt_pvtn,sim_pup,sim_pdn,excel_pup,excel_pdn\n")
drain(out_file)

; --- Sim 1/38: TT (tt_res_bip_dio_disres), Vreg=0.81V, Temp=-34.5C, pvtp=31, pvtn=14 ---
printf("\n>>> [BAD] Running TT Sim 1/38: V=0.81V, T=-34.5C, pvtp=31, pvtn=14 <<<\n")
desVar("tem" -34.5)
desVar("vreg" 0.81)
temp(-34.5)
desVar("pvt0" 1)
desVar("pvt1" 1)
desVar("pvt2" 1)
desVar("pvt3" 1)
desVar("pvt4" 1)
desVar("pvt5" 0)
desVar("pvt6" 0)
desVar("pvt7" 0)
desVar("pvt8" 0)
desVar("pvt9" 0)
desVar("pvt10" 0)
desVar("pvt11" 0)
desVar("pvt12" 0)
desVar("pvt13" 0)
desVar("pvtn0" 0)
desVar("pvtn1" 1)
desVar("pvtn2" 1)
desVar("pvtn3" 1)
desVar("pvtn4" 0)
desVar("pvtn5" 0)
desVar("pvtn6" 0)
desVar("pvtn7" 0)
desVar("pvtn8" 0)
desVar("pvtn9" 0)
desVar("pvtn10" 0)
desVar("pvtn11" 0)
desVar("pvtn12" 0)
desVar("pvtn13" 0)
run()
selectResults('tran)
pup_val = average((clip((v("/vdd" ?result "tran") - v("/outn" ?result "tran")) 2e-07 2.5e-07) / clip(i("/xdrv_p/out" ?result "tran") 2e-07 2.5e-07)))
pdn_val = (average((clip(v("/outp" ?result "tran") 2e-07 2.5e-07) / clip(i("/xdrv_p/out" ?result "tran") 2e-07 2.5e-07))) * -1)
fprintf(out_file "TT,TT,tt_res_bip_dio_disres,0.81,-34.5,247702070,31,14,31,31,%f,%f,49.47,49.77\n" pup_val pdn_val)
drain(out_file)
printf("Result -> pup=%f, pdn=%f (Excel: pup=49.47, pdn=49.77)\n" pup_val pdn_val)

; --- Sim 2/38: TT (tt_res_bip_dio_disres), Vreg=0.81V, Temp=31.0C, pvtp=124, pvtn=60 ---
printf("\n>>> [BAD] Running TT Sim 2/38: V=0.81V, T=31.0C, pvtp=124, pvtn=60 <<<\n")
desVar("tem" 31.0)
desVar("vreg" 0.81)
temp(31.0)
desVar("pvt0" 0)
desVar("pvt1" 0)
desVar("pvt2" 1)
desVar("pvt3" 1)
desVar("pvt4" 1)
desVar("pvt5" 1)
desVar("pvt6" 1)
desVar("pvt7" 0)
desVar("pvt8" 0)
desVar("pvt9" 0)
desVar("pvt10" 0)
desVar("pvt11" 0)
desVar("pvt12" 0)
desVar("pvt13" 0)
desVar("pvtn0" 0)
desVar("pvtn1" 0)
desVar("pvtn2" 1)
desVar("pvtn3" 1)
desVar("pvtn4" 1)
desVar("pvtn5" 1)
desVar("pvtn6" 0)
desVar("pvtn7" 0)
desVar("pvtn8" 0)
desVar("pvtn9" 0)
desVar("pvtn10" 0)
desVar("pvtn11" 0)
desVar("pvtn12" 0)
desVar("pvtn13" 0)
run()
selectResults('tran)
pup_val = average((clip((v("/vdd" ?result "tran") - v("/outn" ?result "tran")) 2e-07 2.5e-07) / clip(i("/xdrv_p/out" ?result "tran") 2e-07 2.5e-07)))
pdn_val = (average((clip(v("/outp" ?result "tran") 2e-07 2.5e-07) / clip(i("/xdrv_p/out" ?result "tran") 2e-07 2.5e-07))) * -1)
fprintf(out_file "TT,TT,tt_res_bip_dio_disres,0.81,31.0,241068330,124,60,60,60,%f,%f,50.31,49.98\n" pup_val pdn_val)
drain(out_file)
printf("Result -> pup=%f, pdn=%f (Excel: pup=50.31, pdn=49.98)\n" pup_val pdn_val)

; --- Sim 3/38: TT (tt_res_bip_dio_disres), Vreg=0.81V, Temp=31.5C, pvtp=124, pvtn=60 ---
printf("\n>>> [BAD] Running TT Sim 3/38: V=0.81V, T=31.5C, pvtp=124, pvtn=60 <<<\n")
desVar("tem" 31.5)
desVar("vreg" 0.81)
temp(31.5)
desVar("pvt0" 0)
desVar("pvt1" 0)
desVar("pvt2" 1)
desVar("pvt3" 1)
desVar("pvt4" 1)
desVar("pvt5" 1)
desVar("pvt6" 1)
desVar("pvt7" 0)
desVar("pvt8" 0)
desVar("pvt9" 0)
desVar("pvt10" 0)
desVar("pvt11" 0)
desVar("pvt12" 0)
desVar("pvt13" 0)
desVar("pvtn0" 0)
desVar("pvtn1" 0)
desVar("pvtn2" 1)
desVar("pvtn3" 1)
desVar("pvtn4" 1)
desVar("pvtn5" 1)
desVar("pvtn6" 0)
desVar("pvtn7" 0)
desVar("pvtn8" 0)
desVar("pvtn9" 0)
desVar("pvtn10" 0)
desVar("pvtn11" 0)
desVar("pvtn12" 0)
desVar("pvtn13" 0)
run()
selectResults('tran)
pup_val = average((clip((v("/vdd" ?result "tran") - v("/outn" ?result "tran")) 2e-07 2.5e-07) / clip(i("/xdrv_p/out" ?result "tran") 2e-07 2.5e-07)))
pdn_val = (average((clip(v("/outp" ?result "tran") 2e-07 2.5e-07) / clip(i("/xdrv_p/out" ?result "tran") 2e-07 2.5e-07))) * -1)
fprintf(out_file "TT,TT,tt_res_bip_dio_disres,0.81,31.5,241054530,124,60,60,60,%f,%f,50.32,49.99\n" pup_val pdn_val)
drain(out_file)
printf("Result -> pup=%f, pdn=%f (Excel: pup=50.32, pdn=49.99)\n" pup_val pdn_val)

; --- Sim 4/38: TT (tt_res_bip_dio_disres), Vreg=0.81V, Temp=45.5C, pvtp=61, pvtn=60 ---
printf("\n>>> [BAD] Running TT Sim 4/38: V=0.81V, T=45.5C, pvtp=61, pvtn=60 <<<\n")
desVar("tem" 45.5)
desVar("vreg" 0.81)
temp(45.5)
desVar("pvt0" 1)
desVar("pvt1" 0)
desVar("pvt2" 1)
desVar("pvt3" 1)
desVar("pvt4" 1)
desVar("pvt5" 1)
desVar("pvt6" 0)
desVar("pvt7" 0)
desVar("pvt8" 0)
desVar("pvt9" 0)
desVar("pvt10" 0)
desVar("pvt11" 0)
desVar("pvt12" 0)
desVar("pvt13" 0)
desVar("pvtn0" 0)
desVar("pvtn1" 0)
desVar("pvtn2" 1)
desVar("pvtn3" 1)
desVar("pvtn4" 1)
desVar("pvtn5" 1)
desVar("pvtn6" 0)
desVar("pvtn7" 0)
desVar("pvtn8" 0)
desVar("pvtn9" 0)
desVar("pvtn10" 0)
desVar("pvtn11" 0)
desVar("pvtn12" 0)
desVar("pvtn13" 0)
run()
selectResults('tran)
pup_val = average((clip((v("/vdd" ?result "tran") - v("/outn" ?result "tran")) 2e-07 2.5e-07) / clip(i("/xdrv_p/out" ?result "tran") 2e-07 2.5e-07)))
pdn_val = (average((clip(v("/outp" ?result "tran") 2e-07 2.5e-07) / clip(i("/xdrv_p/out" ?result "tran") 2e-07 2.5e-07))) * -1)
fprintf(out_file "TT,TT,tt_res_bip_dio_disres,0.81,45.5,240289320,61,60,60,60,%f,%f,50.7,50.3\n" pup_val pdn_val)
drain(out_file)
printf("Result -> pup=%f, pdn=%f (Excel: pup=50.7, pdn=50.3)\n" pup_val pdn_val)

; --- Sim 5/38: TT (tt_res_bip_dio_disres), Vreg=0.83V, Temp=63.0C, pvtp=61, pvtn=60 ---
printf("\n>>> [BAD] Running TT Sim 5/38: V=0.83V, T=63.0C, pvtp=61, pvtn=60 <<<\n")
desVar("tem" 63.0)
desVar("vreg" 0.83)
temp(63.0)
desVar("pvt0" 1)
desVar("pvt1" 0)
desVar("pvt2" 1)
desVar("pvt3" 1)
desVar("pvt4" 1)
desVar("pvt5" 1)
desVar("pvt6" 0)
desVar("pvt7" 0)
desVar("pvt8" 0)
desVar("pvt9" 0)
desVar("pvt10" 0)
desVar("pvt11" 0)
desVar("pvt12" 0)
desVar("pvt13" 0)
desVar("pvtn0" 0)
desVar("pvtn1" 0)
desVar("pvtn2" 1)
desVar("pvtn3" 1)
desVar("pvtn4" 1)
desVar("pvtn5" 1)
desVar("pvtn6" 0)
desVar("pvtn7" 0)
desVar("pvtn8" 0)
desVar("pvtn9" 0)
desVar("pvtn10" 0)
desVar("pvtn11" 0)
desVar("pvtn12" 0)
desVar("pvtn13" 0)
run()
selectResults('tran)
pup_val = average((clip((v("/vdd" ?result "tran") - v("/outn" ?result "tran")) 2e-07 2.5e-07) / clip(i("/xdrv_p/out" ?result "tran") 2e-07 2.5e-07)))
pdn_val = (average((clip(v("/outp" ?result "tran") 2e-07 2.5e-07) / clip(i("/xdrv_p/out" ?result "tran") 2e-07 2.5e-07))) * -1)
fprintf(out_file "TT,TT,tt_res_bip_dio_disres,0.83,63.0,251889710,61,60,61,61,%f,%f,49.67,49.25\n" pup_val pdn_val)
drain(out_file)
printf("Result -> pup=%f, pdn=%f (Excel: pup=49.67, pdn=49.25)\n" pup_val pdn_val)

; --- Sim 6/38: TT (tt_res_bip_dio_disres), Vreg=0.83V, Temp=95.5C, pvtp=62, pvtn=61 ---
printf("\n>>> [BAD] Running TT Sim 6/38: V=0.83V, T=95.5C, pvtp=62, pvtn=61 <<<\n")
desVar("tem" 95.5)
desVar("vreg" 0.83)
temp(95.5)
desVar("pvt0" 0)
desVar("pvt1" 1)
desVar("pvt2" 1)
desVar("pvt3" 1)
desVar("pvt4" 1)
desVar("pvt5" 1)
desVar("pvt6" 0)
desVar("pvt7" 0)
desVar("pvt8" 0)
desVar("pvt9" 0)
desVar("pvt10" 0)
desVar("pvt11" 0)
desVar("pvt12" 0)
desVar("pvt13" 0)
desVar("pvtn0" 1)
desVar("pvtn1" 0)
desVar("pvtn2" 1)
desVar("pvtn3" 1)
desVar("pvtn4" 1)
desVar("pvtn5" 1)
desVar("pvtn6" 0)
desVar("pvtn7" 0)
desVar("pvtn8" 0)
desVar("pvtn9" 0)
desVar("pvtn10" 0)
desVar("pvtn11" 0)
desVar("pvtn12" 0)
desVar("pvtn13" 0)
run()
selectResults('tran)
pup_val = average((clip((v("/vdd" ?result "tran") - v("/outn" ?result "tran")) 2e-07 2.5e-07) / clip(i("/xdrv_p/out" ?result "tran") 2e-07 2.5e-07)))
pdn_val = (average((clip(v("/outp" ?result "tran") 2e-07 2.5e-07) / clip(i("/xdrv_p/out" ?result "tran") 2e-07 2.5e-07))) * -1)
fprintf(out_file "TT,TT,tt_res_bip_dio_disres,0.83,95.5,250046680,62,61,61,61,%f,%f,50.69,49.94\n" pup_val pdn_val)
drain(out_file)
printf("Result -> pup=%f, pdn=%f (Excel: pup=50.69, pdn=49.94)\n" pup_val pdn_val)

; --- Sim 7/38: TT (tt_res_bip_dio_disres), Vreg=0.85V, Temp=23.0C, pvtp=60, pvtn=31 ---
printf("\n>>> [BAD] Running TT Sim 7/38: V=0.85V, T=23.0C, pvtp=60, pvtn=31 <<<\n")
desVar("tem" 23.0)
desVar("vreg" 0.85)
temp(23.0)
desVar("pvt0" 0)
desVar("pvt1" 0)
desVar("pvt2" 1)
desVar("pvt3" 1)
desVar("pvt4" 1)
desVar("pvt5" 1)
desVar("pvt6" 0)
desVar("pvt7" 0)
desVar("pvt8" 0)
desVar("pvt9" 0)
desVar("pvt10" 0)
desVar("pvt11" 0)
desVar("pvt12" 0)
desVar("pvt13" 0)
desVar("pvtn0" 1)
desVar("pvtn1" 1)
desVar("pvtn2" 1)
desVar("pvtn3" 1)
desVar("pvtn4" 1)
desVar("pvtn5" 0)
desVar("pvtn6" 0)
desVar("pvtn7" 0)
desVar("pvtn8" 0)
desVar("pvtn9" 0)
desVar("pvtn10" 0)
desVar("pvtn11" 0)
desVar("pvtn12" 0)
desVar("pvtn13" 0)
run()
selectResults('tran)
pup_val = average((clip((v("/vdd" ?result "tran") - v("/outn" ?result "tran")) 2e-07 2.5e-07) / clip(i("/xdrv_p/out" ?result "tran") 2e-07 2.5e-07)))
pdn_val = (average((clip(v("/outp" ?result "tran") 2e-07 2.5e-07) / clip(i("/xdrv_p/out" ?result "tran") 2e-07 2.5e-07))) * -1)
fprintf(out_file "TT,TT,tt_res_bip_dio_disres,0.85,23.0,269018780,60,31,31,31,%f,%f,50.69,50.39\n" pup_val pdn_val)
drain(out_file)
printf("Result -> pup=%f, pdn=%f (Excel: pup=50.69, pdn=50.39)\n" pup_val pdn_val)

; --- Sim 8/38: TT (tt_res_bip_dio_disres), Vreg=0.85V, Temp=35.5C, pvtp=60, pvtn=31 ---
printf("\n>>> [BAD] Running TT Sim 8/38: V=0.85V, T=35.5C, pvtp=60, pvtn=31 <<<\n")
desVar("tem" 35.5)
desVar("vreg" 0.85)
temp(35.5)
desVar("pvt0" 0)
desVar("pvt1" 0)
desVar("pvt2" 1)
desVar("pvt3" 1)
desVar("pvt4" 1)
desVar("pvt5" 1)
desVar("pvt6" 0)
desVar("pvt7" 0)
desVar("pvt8" 0)
desVar("pvt9" 0)
desVar("pvt10" 0)
desVar("pvt11" 0)
desVar("pvt12" 0)
desVar("pvt13" 0)
desVar("pvtn0" 1)
desVar("pvtn1" 1)
desVar("pvtn2" 1)
desVar("pvtn3" 1)
desVar("pvtn4" 1)
desVar("pvtn5" 0)
desVar("pvtn6" 0)
desVar("pvtn7" 0)
desVar("pvtn8" 0)
desVar("pvtn9" 0)
desVar("pvtn10" 0)
desVar("pvtn11" 0)
desVar("pvtn12" 0)
desVar("pvtn13" 0)
run()
selectResults('tran)
pup_val = average((clip((v("/vdd" ?result "tran") - v("/outn" ?result "tran")) 2e-07 2.5e-07) / clip(i("/xdrv_p/out" ?result "tran") 2e-07 2.5e-07)))
pdn_val = (average((clip(v("/outp" ?result "tran") 2e-07 2.5e-07) / clip(i("/xdrv_p/out" ?result "tran") 2e-07 2.5e-07))) * -1)
fprintf(out_file "TT,TT,tt_res_bip_dio_disres,0.85,35.5,267232530,60,31,60,60,%f,%f,49.8,49.6\n" pup_val pdn_val)
drain(out_file)
printf("Result -> pup=%f, pdn=%f (Excel: pup=49.8, pdn=49.6)\n" pup_val pdn_val)

; --- Sim 9/38: TT (tt_res_bip_dio_disres), Vreg=0.85V, Temp=105.0C, pvtp=61, pvtn=61 ---
printf("\n>>> [BAD] Running TT Sim 9/38: V=0.85V, T=105.0C, pvtp=61, pvtn=61 <<<\n")
desVar("tem" 105.0)
desVar("vreg" 0.85)
temp(105.0)
desVar("pvt0" 1)
desVar("pvt1" 0)
desVar("pvt2" 1)
desVar("pvt3" 1)
desVar("pvt4" 1)
desVar("pvt5" 1)
desVar("pvt6" 0)
desVar("pvt7" 0)
desVar("pvt8" 0)
desVar("pvt9" 0)
desVar("pvt10" 0)
desVar("pvt11" 0)
desVar("pvt12" 0)
desVar("pvt13" 0)
desVar("pvtn0" 1)
desVar("pvtn1" 0)
desVar("pvtn2" 1)
desVar("pvtn3" 1)
desVar("pvtn4" 1)
desVar("pvtn5" 1)
desVar("pvtn6" 0)
desVar("pvtn7" 0)
desVar("pvtn8" 0)
desVar("pvtn9" 0)
desVar("pvtn10" 0)
desVar("pvtn11" 0)
desVar("pvtn12" 0)
desVar("pvtn13" 0)
run()
selectResults('tran)
pup_val = average((clip((v("/vdd" ?result "tran") - v("/outn" ?result "tran")) 2e-07 2.5e-07) / clip(i("/xdrv_p/out" ?result "tran") 2e-07 2.5e-07)))
pdn_val = (average((clip(v("/outp" ?result "tran") 2e-07 2.5e-07) / clip(i("/xdrv_p/out" ?result "tran") 2e-07 2.5e-07))) * -1)
fprintf(out_file "TT,TT,tt_res_bip_dio_disres,0.85,105.0,260448600,61,61,62,61,%f,%f,49.51,49.91\n" pup_val pdn_val)
drain(out_file)
printf("Result -> pup=%f, pdn=%f (Excel: pup=49.51, pdn=49.91)\n" pup_val pdn_val)

; --- Sim 10/38: TT (tt_res_bip_dio_disres), Vreg=0.87V, Temp=31.0C, pvtp=122, pvtn=31 ---
printf("\n>>> [BAD] Running TT Sim 10/38: V=0.87V, T=31.0C, pvtp=122, pvtn=31 <<<\n")
desVar("tem" 31.0)
desVar("vreg" 0.87)
temp(31.0)
desVar("pvt0" 0)
desVar("pvt1" 1)
desVar("pvt2" 0)
desVar("pvt3" 1)
desVar("pvt4" 1)
desVar("pvt5" 1)
desVar("pvt6" 1)
desVar("pvt7" 0)
desVar("pvt8" 0)
desVar("pvt9" 0)
desVar("pvt10" 0)
desVar("pvt11" 0)
desVar("pvt12" 0)
desVar("pvt13" 0)
desVar("pvtn0" 1)
desVar("pvtn1" 1)
desVar("pvtn2" 1)
desVar("pvtn3" 1)
desVar("pvtn4" 1)
desVar("pvtn5" 0)
desVar("pvtn6" 0)
desVar("pvtn7" 0)
desVar("pvtn8" 0)
desVar("pvtn9" 0)
desVar("pvtn10" 0)
desVar("pvtn11" 0)
desVar("pvtn12" 0)
desVar("pvtn13" 0)
run()
selectResults('tran)
pup_val = average((clip((v("/vdd" ?result "tran") - v("/outn" ?result "tran")) 2e-07 2.5e-07) / clip(i("/xdrv_p/out" ?result "tran") 2e-07 2.5e-07)))
pdn_val = (average((clip(v("/outp" ?result "tran") 2e-07 2.5e-07) / clip(i("/xdrv_p/out" ?result "tran") 2e-07 2.5e-07))) * -1)
fprintf(out_file "TT,TT,tt_res_bip_dio_disres,0.87,31.0,280928170,122,31,31,31,%f,%f,50.65,50.38\n" pup_val pdn_val)
drain(out_file)
printf("Result -> pup=%f, pdn=%f (Excel: pup=50.65, pdn=50.38)\n" pup_val pdn_val)

; --- Sim 11/38: TT (tt_res_bip_dio_disres), Vreg=0.87V, Temp=31.5C, pvtp=122, pvtn=31 ---
printf("\n>>> [BAD] Running TT Sim 11/38: V=0.87V, T=31.5C, pvtp=122, pvtn=31 <<<\n")
desVar("tem" 31.5)
desVar("vreg" 0.87)
temp(31.5)
desVar("pvt0" 0)
desVar("pvt1" 1)
desVar("pvt2" 0)
desVar("pvt3" 1)
desVar("pvt4" 1)
desVar("pvt5" 1)
desVar("pvt6" 1)
desVar("pvt7" 0)
desVar("pvt8" 0)
desVar("pvt9" 0)
desVar("pvt10" 0)
desVar("pvt11" 0)
desVar("pvt12" 0)
desVar("pvt13" 0)
desVar("pvtn0" 1)
desVar("pvtn1" 1)
desVar("pvtn2" 1)
desVar("pvtn3" 1)
desVar("pvtn4" 1)
desVar("pvtn5" 0)
desVar("pvtn6" 0)
desVar("pvtn7" 0)
desVar("pvtn8" 0)
desVar("pvtn9" 0)
desVar("pvtn10" 0)
desVar("pvtn11" 0)
desVar("pvtn12" 0)
desVar("pvtn13" 0)
run()
selectResults('tran)
pup_val = average((clip((v("/vdd" ?result "tran") - v("/outn" ?result "tran")) 2e-07 2.5e-07) / clip(i("/xdrv_p/out" ?result "tran") 2e-07 2.5e-07)))
pdn_val = (average((clip(v("/outp" ?result "tran") 2e-07 2.5e-07) / clip(i("/xdrv_p/out" ?result "tran") 2e-07 2.5e-07))) * -1)
fprintf(out_file "TT,TT,tt_res_bip_dio_disres,0.87,31.5,280842670,122,31,31,31,%f,%f,50.66,50.39\n" pup_val pdn_val)
drain(out_file)
printf("Result -> pup=%f, pdn=%f (Excel: pup=50.66, pdn=50.39)\n" pup_val pdn_val)

; --- Sim 12/38: TT (tt_res_bip_dio_disres), Vreg=0.87V, Temp=124.0C, pvtp=62, pvtn=127 ---
printf("\n>>> [BAD] Running TT Sim 12/38: V=0.87V, T=124.0C, pvtp=62, pvtn=127 <<<\n")
desVar("tem" 124.0)
desVar("vreg" 0.87)
temp(124.0)
desVar("pvt0" 0)
desVar("pvt1" 1)
desVar("pvt2" 1)
desVar("pvt3" 1)
desVar("pvt4" 1)
desVar("pvt5" 1)
desVar("pvt6" 0)
desVar("pvt7" 0)
desVar("pvt8" 0)
desVar("pvt9" 0)
desVar("pvt10" 0)
desVar("pvt11" 0)
desVar("pvt12" 0)
desVar("pvt13" 0)
desVar("pvtn0" 1)
desVar("pvtn1" 1)
desVar("pvtn2" 1)
desVar("pvtn3" 1)
desVar("pvtn4" 1)
desVar("pvtn5" 1)
desVar("pvtn6" 1)
desVar("pvtn7" 0)
desVar("pvtn8" 0)
desVar("pvtn9" 0)
desVar("pvtn10" 0)
desVar("pvtn11" 0)
desVar("pvtn12" 0)
desVar("pvtn13" 0)
run()
selectResults('tran)
pup_val = average((clip((v("/vdd" ?result "tran") - v("/outn" ?result "tran")) 2e-07 2.5e-07) / clip(i("/xdrv_p/out" ?result "tran") 2e-07 2.5e-07)))
pdn_val = (average((clip(v("/outp" ?result "tran") 2e-07 2.5e-07) / clip(i("/xdrv_p/out" ?result "tran") 2e-07 2.5e-07))) * -1)
fprintf(out_file "TT,TT,tt_res_bip_dio_disres,0.87,124.0,269348730,62,127,62,61,%f,%f,49.94,50.1\n" pup_val pdn_val)
drain(out_file)
printf("Result -> pup=%f, pdn=%f (Excel: pup=49.94, pdn=50.1)\n" pup_val pdn_val)

; --- Sim 13/38: TT (tt_res_bip_dio_disres), Vreg=0.87V, Temp=124.5C, pvtp=62, pvtn=127 ---
printf("\n>>> [BAD] Running TT Sim 13/38: V=0.87V, T=124.5C, pvtp=62, pvtn=127 <<<\n")
desVar("tem" 124.5)
desVar("vreg" 0.87)
temp(124.5)
desVar("pvt0" 0)
desVar("pvt1" 1)
desVar("pvt2" 1)
desVar("pvt3" 1)
desVar("pvt4" 1)
desVar("pvt5" 1)
desVar("pvt6" 0)
desVar("pvt7" 0)
desVar("pvt8" 0)
desVar("pvt9" 0)
desVar("pvt10" 0)
desVar("pvt11" 0)
desVar("pvt12" 0)
desVar("pvt13" 0)
desVar("pvtn0" 1)
desVar("pvtn1" 1)
desVar("pvtn2" 1)
desVar("pvtn3" 1)
desVar("pvtn4" 1)
desVar("pvtn5" 1)
desVar("pvtn6" 1)
desVar("pvtn7" 0)
desVar("pvtn8" 0)
desVar("pvtn9" 0)
desVar("pvtn10" 0)
desVar("pvtn11" 0)
desVar("pvtn12" 0)
desVar("pvtn13" 0)
run()
selectResults('tran)
pup_val = average((clip((v("/vdd" ?result "tran") - v("/outn" ?result "tran")) 2e-07 2.5e-07) / clip(i("/xdrv_p/out" ?result "tran") 2e-07 2.5e-07)))
pdn_val = (average((clip(v("/outp" ?result "tran") 2e-07 2.5e-07) / clip(i("/xdrv_p/out" ?result "tran") 2e-07 2.5e-07))) * -1)
fprintf(out_file "TT,TT,tt_res_bip_dio_disres,0.87,124.5,269313590,62,127,62,61,%f,%f,49.96,50.11\n" pup_val pdn_val)
drain(out_file)
printf("Result -> pup=%f, pdn=%f (Excel: pup=49.96, pdn=50.11)\n" pup_val pdn_val)

; --- Sim 14/38: TT (tt_res_bip_dio_disres), Vreg=0.87V, Temp=125.0C, pvtp=62, pvtn=127 ---
printf("\n>>> [BAD] Running TT Sim 14/38: V=0.87V, T=125.0C, pvtp=62, pvtn=127 <<<\n")
desVar("tem" 125.0)
desVar("vreg" 0.87)
temp(125.0)
desVar("pvt0" 0)
desVar("pvt1" 1)
desVar("pvt2" 1)
desVar("pvt3" 1)
desVar("pvt4" 1)
desVar("pvt5" 1)
desVar("pvt6" 0)
desVar("pvt7" 0)
desVar("pvt8" 0)
desVar("pvt9" 0)
desVar("pvt10" 0)
desVar("pvt11" 0)
desVar("pvt12" 0)
desVar("pvt13" 0)
desVar("pvtn0" 1)
desVar("pvtn1" 1)
desVar("pvtn2" 1)
desVar("pvtn3" 1)
desVar("pvtn4" 1)
desVar("pvtn5" 1)
desVar("pvtn6" 1)
desVar("pvtn7" 0)
desVar("pvtn8" 0)
desVar("pvtn9" 0)
desVar("pvtn10" 0)
desVar("pvtn11" 0)
desVar("pvtn12" 0)
desVar("pvtn13" 0)
run()
selectResults('tran)
pup_val = average((clip((v("/vdd" ?result "tran") - v("/outn" ?result "tran")) 2e-07 2.5e-07) / clip(i("/xdrv_p/out" ?result "tran") 2e-07 2.5e-07)))
pdn_val = (average((clip(v("/outp" ?result "tran") 2e-07 2.5e-07) / clip(i("/xdrv_p/out" ?result "tran") 2e-07 2.5e-07))) * -1)
fprintf(out_file "TT,TT,tt_res_bip_dio_disres,0.87,125.0,269262550,62,127,62,61,%f,%f,49.98,50.12\n" pup_val pdn_val)
drain(out_file)
printf("Result -> pup=%f, pdn=%f (Excel: pup=49.98, pdn=50.12)\n" pup_val pdn_val)

; --- Sim 15/38: TT (tt_res_bip_dio_disres), Vreg=0.89V, Temp=-36.5C, pvtp=30, pvtn=14 ---
printf("\n>>> [BAD] Running TT Sim 15/38: V=0.89V, T=-36.5C, pvtp=30, pvtn=14 <<<\n")
desVar("tem" -36.5)
desVar("vreg" 0.89)
temp(-36.5)
desVar("pvt0" 0)
desVar("pvt1" 1)
desVar("pvt2" 1)
desVar("pvt3" 1)
desVar("pvt4" 1)
desVar("pvt5" 0)
desVar("pvt6" 0)
desVar("pvt7" 0)
desVar("pvt8" 0)
desVar("pvt9" 0)
desVar("pvt10" 0)
desVar("pvt11" 0)
desVar("pvt12" 0)
desVar("pvt13" 0)
desVar("pvtn0" 0)
desVar("pvtn1" 1)
desVar("pvtn2" 1)
desVar("pvtn3" 1)
desVar("pvtn4" 0)
desVar("pvtn5" 0)
desVar("pvtn6" 0)
desVar("pvtn7" 0)
desVar("pvtn8" 0)
desVar("pvtn9" 0)
desVar("pvtn10" 0)
desVar("pvtn11" 0)
desVar("pvtn12" 0)
desVar("pvtn13" 0)
run()
selectResults('tran)
pup_val = average((clip((v("/vdd" ?result "tran") - v("/outn" ?result "tran")) 2e-07 2.5e-07) / clip(i("/xdrv_p/out" ?result "tran") 2e-07 2.5e-07)))
pdn_val = (average((clip(v("/outp" ?result "tran") 2e-07 2.5e-07) / clip(i("/xdrv_p/out" ?result "tran") 2e-07 2.5e-07))) * -1)
fprintf(out_file "TT,TT,tt_res_bip_dio_disres,0.89,-36.5,313270140,30,14,30,30,%f,%f,49.82,49.78\n" pup_val pdn_val)
drain(out_file)
printf("Result -> pup=%f, pdn=%f (Excel: pup=49.82, pdn=49.78)\n" pup_val pdn_val)

; --- Sim 16/38: TT (tt_res_bip_dio_disres), Vreg=0.89V, Temp=-4.5C, pvtp=31, pvtn=30 ---
printf("\n>>> [BAD] Running TT Sim 16/38: V=0.89V, T=-4.5C, pvtp=31, pvtn=30 <<<\n")
desVar("tem" -4.5)
desVar("vreg" 0.89)
temp(-4.5)
desVar("pvt0" 1)
desVar("pvt1" 1)
desVar("pvt2" 1)
desVar("pvt3" 1)
desVar("pvt4" 1)
desVar("pvt5" 0)
desVar("pvt6" 0)
desVar("pvt7" 0)
desVar("pvt8" 0)
desVar("pvt9" 0)
desVar("pvt10" 0)
desVar("pvt11" 0)
desVar("pvt12" 0)
desVar("pvt13" 0)
desVar("pvtn0" 0)
desVar("pvtn1" 1)
desVar("pvtn2" 1)
desVar("pvtn3" 1)
desVar("pvtn4" 1)
desVar("pvtn5" 0)
desVar("pvtn6" 0)
desVar("pvtn7" 0)
desVar("pvtn8" 0)
desVar("pvtn9" 0)
desVar("pvtn10" 0)
desVar("pvtn11" 0)
desVar("pvtn12" 0)
desVar("pvtn13" 0)
run()
selectResults('tran)
pup_val = average((clip((v("/vdd" ?result "tran") - v("/outn" ?result "tran")) 2e-07 2.5e-07) / clip(i("/xdrv_p/out" ?result "tran") 2e-07 2.5e-07)))
pdn_val = (average((clip(v("/outp" ?result "tran") 2e-07 2.5e-07) / clip(i("/xdrv_p/out" ?result "tran") 2e-07 2.5e-07))) * -1)
fprintf(out_file "TT,TT,tt_res_bip_dio_disres,0.89,-4.5,302623780,31,30,30,30,%f,%f,50.69,50.59\n" pup_val pdn_val)
drain(out_file)
printf("Result -> pup=%f, pdn=%f (Excel: pup=50.69, pdn=50.59)\n" pup_val pdn_val)

; --- Sim 17/38: TT (tt_res_bip_dio_disres), Vreg=0.89V, Temp=0.0C, pvtp=31, pvtn=30 ---
printf("\n>>> [BAD] Running TT Sim 17/38: V=0.89V, T=0.0C, pvtp=31, pvtn=30 <<<\n")
desVar("tem" 0.0)
desVar("vreg" 0.89)
temp(0.0)
desVar("pvt0" 1)
desVar("pvt1" 1)
desVar("pvt2" 1)
desVar("pvt3" 1)
desVar("pvt4" 1)
desVar("pvt5" 0)
desVar("pvt6" 0)
desVar("pvt7" 0)
desVar("pvt8" 0)
desVar("pvt9" 0)
desVar("pvt10" 0)
desVar("pvt11" 0)
desVar("pvt12" 0)
desVar("pvt13" 0)
desVar("pvtn0" 0)
desVar("pvtn1" 1)
desVar("pvtn2" 1)
desVar("pvtn3" 1)
desVar("pvtn4" 1)
desVar("pvtn5" 0)
desVar("pvtn6" 0)
desVar("pvtn7" 0)
desVar("pvtn8" 0)
desVar("pvtn9" 0)
desVar("pvtn10" 0)
desVar("pvtn11" 0)
desVar("pvtn12" 0)
desVar("pvtn13" 0)
run()
selectResults('tran)
pup_val = average((clip((v("/vdd" ?result "tran") - v("/outn" ?result "tran")) 2e-07 2.5e-07) / clip(i("/xdrv_p/out" ?result "tran") 2e-07 2.5e-07)))
pdn_val = (average((clip(v("/outp" ?result "tran") 2e-07 2.5e-07) / clip(i("/xdrv_p/out" ?result "tran") 2e-07 2.5e-07))) * -1)
fprintf(out_file "TT,TT,tt_res_bip_dio_disres,0.89,0.0,301362760,31,30,31,31,%f,%f,49.53,49.44\n" pup_val pdn_val)
drain(out_file)
printf("Result -> pup=%f, pdn=%f (Excel: pup=49.53, pdn=49.44)\n" pup_val pdn_val)

; --- Sim 18/38: TT (tt_res_bip_dio_disres), Vreg=0.89V, Temp=84.0C, pvtp=60, pvtn=60 ---
printf("\n>>> [BAD] Running TT Sim 18/38: V=0.89V, T=84.0C, pvtp=60, pvtn=60 <<<\n")
desVar("tem" 84.0)
desVar("vreg" 0.89)
temp(84.0)
desVar("pvt0" 0)
desVar("pvt1" 0)
desVar("pvt2" 1)
desVar("pvt3" 1)
desVar("pvt4" 1)
desVar("pvt5" 1)
desVar("pvt6" 0)
desVar("pvt7" 0)
desVar("pvt8" 0)
desVar("pvt9" 0)
desVar("pvt10" 0)
desVar("pvt11" 0)
desVar("pvt12" 0)
desVar("pvt13" 0)
desVar("pvtn0" 0)
desVar("pvtn1" 0)
desVar("pvtn2" 1)
desVar("pvtn3" 1)
desVar("pvtn4" 1)
desVar("pvtn5" 1)
desVar("pvtn6" 0)
desVar("pvtn7" 0)
desVar("pvtn8" 0)
desVar("pvtn9" 0)
desVar("pvtn10" 0)
desVar("pvtn11" 0)
desVar("pvtn12" 0)
desVar("pvtn13" 0)
run()
selectResults('tran)
pup_val = average((clip((v("/vdd" ?result "tran") - v("/outn" ?result "tran")) 2e-07 2.5e-07) / clip(i("/xdrv_p/out" ?result "tran") 2e-07 2.5e-07)))
pdn_val = (average((clip(v("/outp" ?result "tran") 2e-07 2.5e-07) / clip(i("/xdrv_p/out" ?result "tran") 2e-07 2.5e-07))) * -1)
fprintf(out_file "TT,TT,tt_res_bip_dio_disres,0.89,84.0,284320560,60,60,61,60,%f,%f,49.48,50.26\n" pup_val pdn_val)
drain(out_file)
printf("Result -> pup=%f, pdn=%f (Excel: pup=49.48, pdn=50.26)\n" pup_val pdn_val)

; --- Sim 19/38: TT (tt_res_bip_dio_disres), Vreg=0.91V, Temp=6.5C, pvtp=31, pvtn=124 ---
printf("\n>>> [BAD] Running TT Sim 19/38: V=0.91V, T=6.5C, pvtp=31, pvtn=124 <<<\n")
desVar("tem" 6.5)
desVar("vreg" 0.91)
temp(6.5)
desVar("pvt0" 1)
desVar("pvt1" 1)
desVar("pvt2" 1)
desVar("pvt3" 1)
desVar("pvt4" 1)
desVar("pvt5" 0)
desVar("pvt6" 0)
desVar("pvt7" 0)
desVar("pvt8" 0)
desVar("pvt9" 0)
desVar("pvt10" 0)
desVar("pvt11" 0)
desVar("pvt12" 0)
desVar("pvt13" 0)
desVar("pvtn0" 0)
desVar("pvtn1" 0)
desVar("pvtn2" 1)
desVar("pvtn3" 1)
desVar("pvtn4" 1)
desVar("pvtn5" 1)
desVar("pvtn6" 1)
desVar("pvtn7" 0)
desVar("pvtn8" 0)
desVar("pvtn9" 0)
desVar("pvtn10" 0)
desVar("pvtn11" 0)
desVar("pvtn12" 0)
desVar("pvtn13" 0)
run()
selectResults('tran)
pup_val = average((clip((v("/vdd" ?result "tran") - v("/outn" ?result "tran")) 2e-07 2.5e-07) / clip(i("/xdrv_p/out" ?result "tran") 2e-07 2.5e-07)))
pdn_val = (average((clip(v("/outp" ?result "tran") 2e-07 2.5e-07) / clip(i("/xdrv_p/out" ?result "tran") 2e-07 2.5e-07))) * -1)
fprintf(out_file "TT,TT,tt_res_bip_dio_disres,0.91,6.5,313166780,31,124,31,30,%f,%f,49.49,50.67\n" pup_val pdn_val)
drain(out_file)
printf("Result -> pup=%f, pdn=%f (Excel: pup=49.49, pdn=50.67)\n" pup_val pdn_val)

; --- Sim 20/38: TT (tt_res_bip_dio_disres), Vreg=0.91V, Temp=7.0C, pvtp=31, pvtn=124 ---
printf("\n>>> [BAD] Running TT Sim 20/38: V=0.91V, T=7.0C, pvtp=31, pvtn=124 <<<\n")
desVar("tem" 7.0)
desVar("vreg" 0.91)
temp(7.0)
desVar("pvt0" 1)
desVar("pvt1" 1)
desVar("pvt2" 1)
desVar("pvt3" 1)
desVar("pvt4" 1)
desVar("pvt5" 0)
desVar("pvt6" 0)
desVar("pvt7" 0)
desVar("pvt8" 0)
desVar("pvt9" 0)
desVar("pvt10" 0)
desVar("pvt11" 0)
desVar("pvt12" 0)
desVar("pvt13" 0)
desVar("pvtn0" 0)
desVar("pvtn1" 0)
desVar("pvtn2" 1)
desVar("pvtn3" 1)
desVar("pvtn4" 1)
desVar("pvtn5" 1)
desVar("pvtn6" 1)
desVar("pvtn7" 0)
desVar("pvtn8" 0)
desVar("pvtn9" 0)
desVar("pvtn10" 0)
desVar("pvtn11" 0)
desVar("pvtn12" 0)
desVar("pvtn13" 0)
run()
selectResults('tran)
pup_val = average((clip((v("/vdd" ?result "tran") - v("/outn" ?result "tran")) 2e-07 2.5e-07) / clip(i("/xdrv_p/out" ?result "tran") 2e-07 2.5e-07)))
pdn_val = (average((clip(v("/outp" ?result "tran") 2e-07 2.5e-07) / clip(i("/xdrv_p/out" ?result "tran") 2e-07 2.5e-07))) * -1)
fprintf(out_file "TT,TT,tt_res_bip_dio_disres,0.91,7.0,313029740,31,124,31,30,%f,%f,49.5,50.68\n" pup_val pdn_val)
drain(out_file)
printf("Result -> pup=%f, pdn=%f (Excel: pup=49.5, pdn=50.68)\n" pup_val pdn_val)

; --- Sim 21/38: TT (tt_res_bip_dio_disres), Vreg=0.91V, Temp=7.5C, pvtp=31, pvtn=124 ---
printf("\n>>> [BAD] Running TT Sim 21/38: V=0.91V, T=7.5C, pvtp=31, pvtn=124 <<<\n")
desVar("tem" 7.5)
desVar("vreg" 0.91)
temp(7.5)
desVar("pvt0" 1)
desVar("pvt1" 1)
desVar("pvt2" 1)
desVar("pvt3" 1)
desVar("pvt4" 1)
desVar("pvt5" 0)
desVar("pvt6" 0)
desVar("pvt7" 0)
desVar("pvt8" 0)
desVar("pvt9" 0)
desVar("pvt10" 0)
desVar("pvt11" 0)
desVar("pvt12" 0)
desVar("pvt13" 0)
desVar("pvtn0" 0)
desVar("pvtn1" 0)
desVar("pvtn2" 1)
desVar("pvtn3" 1)
desVar("pvtn4" 1)
desVar("pvtn5" 1)
desVar("pvtn6" 1)
desVar("pvtn7" 0)
desVar("pvtn8" 0)
desVar("pvtn9" 0)
desVar("pvtn10" 0)
desVar("pvtn11" 0)
desVar("pvtn12" 0)
desVar("pvtn13" 0)
run()
selectResults('tran)
pup_val = average((clip((v("/vdd" ?result "tran") - v("/outn" ?result "tran")) 2e-07 2.5e-07) / clip(i("/xdrv_p/out" ?result "tran") 2e-07 2.5e-07)))
pdn_val = (average((clip(v("/outp" ?result "tran") 2e-07 2.5e-07) / clip(i("/xdrv_p/out" ?result "tran") 2e-07 2.5e-07))) * -1)
fprintf(out_file "TT,TT,tt_res_bip_dio_disres,0.91,7.5,312860670,31,124,31,31,%f,%f,49.51,49.44\n" pup_val pdn_val)
drain(out_file)
printf("Result -> pup=%f, pdn=%f (Excel: pup=49.51, pdn=49.44)\n" pup_val pdn_val)

; --- Sim 22/38: TT (tt_res_bip_dio_disres), Vreg=0.91V, Temp=8.0C, pvtp=31, pvtn=124 ---
printf("\n>>> [BAD] Running TT Sim 22/38: V=0.91V, T=8.0C, pvtp=31, pvtn=124 <<<\n")
desVar("tem" 8.0)
desVar("vreg" 0.91)
temp(8.0)
desVar("pvt0" 1)
desVar("pvt1" 1)
desVar("pvt2" 1)
desVar("pvt3" 1)
desVar("pvt4" 1)
desVar("pvt5" 0)
desVar("pvt6" 0)
desVar("pvt7" 0)
desVar("pvt8" 0)
desVar("pvt9" 0)
desVar("pvt10" 0)
desVar("pvt11" 0)
desVar("pvt12" 0)
desVar("pvt13" 0)
desVar("pvtn0" 0)
desVar("pvtn1" 0)
desVar("pvtn2" 1)
desVar("pvtn3" 1)
desVar("pvtn4" 1)
desVar("pvtn5" 1)
desVar("pvtn6" 1)
desVar("pvtn7" 0)
desVar("pvtn8" 0)
desVar("pvtn9" 0)
desVar("pvtn10" 0)
desVar("pvtn11" 0)
desVar("pvtn12" 0)
desVar("pvtn13" 0)
run()
selectResults('tran)
pup_val = average((clip((v("/vdd" ?result "tran") - v("/outn" ?result "tran")) 2e-07 2.5e-07) / clip(i("/xdrv_p/out" ?result "tran") 2e-07 2.5e-07)))
pdn_val = (average((clip(v("/outp" ?result "tran") 2e-07 2.5e-07) / clip(i("/xdrv_p/out" ?result "tran") 2e-07 2.5e-07))) * -1)
fprintf(out_file "TT,TT,tt_res_bip_dio_disres,0.91,8.0,312722260,31,124,31,31,%f,%f,49.53,49.45\n" pup_val pdn_val)
drain(out_file)
printf("Result -> pup=%f, pdn=%f (Excel: pup=49.53, pdn=49.45)\n" pup_val pdn_val)

; --- Sim 23/38: TT (tt_res_bip_dio_disres), Vreg=0.93V, Temp=-3.5C, pvtp=122, pvtn=30 ---
printf("\n>>> [BAD] Running TT Sim 23/38: V=0.93V, T=-3.5C, pvtp=122, pvtn=30 <<<\n")
desVar("tem" -3.5)
desVar("vreg" 0.93)
temp(-3.5)
desVar("pvt0" 0)
desVar("pvt1" 1)
desVar("pvt2" 0)
desVar("pvt3" 1)
desVar("pvt4" 1)
desVar("pvt5" 1)
desVar("pvt6" 1)
desVar("pvt7" 0)
desVar("pvt8" 0)
desVar("pvt9" 0)
desVar("pvt10" 0)
desVar("pvt11" 0)
desVar("pvt12" 0)
desVar("pvt13" 0)
desVar("pvtn0" 0)
desVar("pvtn1" 1)
desVar("pvtn2" 1)
desVar("pvtn3" 1)
desVar("pvtn4" 1)
desVar("pvtn5" 0)
desVar("pvtn6" 0)
desVar("pvtn7" 0)
desVar("pvtn8" 0)
desVar("pvtn9" 0)
desVar("pvtn10" 0)
desVar("pvtn11" 0)
desVar("pvtn12" 0)
desVar("pvtn13" 0)
run()
selectResults('tran)
pup_val = average((clip((v("/vdd" ?result "tran") - v("/outn" ?result "tran")) 2e-07 2.5e-07) / clip(i("/xdrv_p/out" ?result "tran") 2e-07 2.5e-07)))
pdn_val = (average((clip(v("/outp" ?result "tran") 2e-07 2.5e-07) / clip(i("/xdrv_p/out" ?result "tran") 2e-07 2.5e-07))) * -1)
fprintf(out_file "TT,TT,tt_res_bip_dio_disres,0.93,-3.5,330036190,122,30,30,30,%f,%f,50.29,50.26\n" pup_val pdn_val)
drain(out_file)
printf("Result -> pup=%f, pdn=%f (Excel: pup=50.29, pdn=50.26)\n" pup_val pdn_val)

; --- Sim 24/38: TT (tt_res_bip_dio_disres), Vreg=0.93V, Temp=15.5C, pvtp=31, pvtn=30 ---
printf("\n>>> [BAD] Running TT Sim 24/38: V=0.93V, T=15.5C, pvtp=31, pvtn=30 <<<\n")
desVar("tem" 15.5)
desVar("vreg" 0.93)
temp(15.5)
desVar("pvt0" 1)
desVar("pvt1" 1)
desVar("pvt2" 1)
desVar("pvt3" 1)
desVar("pvt4" 1)
desVar("pvt5" 0)
desVar("pvt6" 0)
desVar("pvt7" 0)
desVar("pvt8" 0)
desVar("pvt9" 0)
desVar("pvt10" 0)
desVar("pvt11" 0)
desVar("pvt12" 0)
desVar("pvt13" 0)
desVar("pvtn0" 0)
desVar("pvtn1" 1)
desVar("pvtn2" 1)
desVar("pvtn3" 1)
desVar("pvtn4" 1)
desVar("pvtn5" 0)
desVar("pvtn6" 0)
desVar("pvtn7" 0)
desVar("pvtn8" 0)
desVar("pvtn9" 0)
desVar("pvtn10" 0)
desVar("pvtn11" 0)
desVar("pvtn12" 0)
desVar("pvtn13" 0)
run()
selectResults('tran)
pup_val = average((clip((v("/vdd" ?result "tran") - v("/outn" ?result "tran")) 2e-07 2.5e-07) / clip(i("/xdrv_p/out" ?result "tran") 2e-07 2.5e-07)))
pdn_val = (average((clip(v("/outp" ?result "tran") 2e-07 2.5e-07) / clip(i("/xdrv_p/out" ?result "tran") 2e-07 2.5e-07))) * -1)
fprintf(out_file "TT,TT,tt_res_bip_dio_disres,0.93,15.5,323451970,31,30,31,31,%f,%f,49.53,49.46\n" pup_val pdn_val)
drain(out_file)
printf("Result -> pup=%f, pdn=%f (Excel: pup=49.53, pdn=49.46)\n" pup_val pdn_val)

; --- Sim 25/38: TT (tt_res_bip_dio_disres), Vreg=0.93V, Temp=118.0C, pvtp=61, pvtn=61 ---
printf("\n>>> [BAD] Running TT Sim 25/38: V=0.93V, T=118.0C, pvtp=61, pvtn=61 <<<\n")
desVar("tem" 118.0)
desVar("vreg" 0.93)
temp(118.0)
desVar("pvt0" 1)
desVar("pvt1" 0)
desVar("pvt2" 1)
desVar("pvt3" 1)
desVar("pvt4" 1)
desVar("pvt5" 1)
desVar("pvt6" 0)
desVar("pvt7" 0)
desVar("pvt8" 0)
desVar("pvt9" 0)
desVar("pvt10" 0)
desVar("pvt11" 0)
desVar("pvt12" 0)
desVar("pvt13" 0)
desVar("pvtn0" 1)
desVar("pvtn1" 0)
desVar("pvtn2" 1)
desVar("pvtn3" 1)
desVar("pvtn4" 1)
desVar("pvtn5" 1)
desVar("pvtn6" 0)
desVar("pvtn7" 0)
desVar("pvtn8" 0)
desVar("pvtn9" 0)
desVar("pvtn10" 0)
desVar("pvtn11" 0)
desVar("pvtn12" 0)
desVar("pvtn13" 0)
run()
selectResults('tran)
pup_val = average((clip((v("/vdd" ?result "tran") - v("/outn" ?result "tran")) 2e-07 2.5e-07) / clip(i("/xdrv_p/out" ?result "tran") 2e-07 2.5e-07)))
pdn_val = (average((clip(v("/outp" ?result "tran") 2e-07 2.5e-07) / clip(i("/xdrv_p/out" ?result "tran") 2e-07 2.5e-07))) * -1)
fprintf(out_file "TT,TT,tt_res_bip_dio_disres,0.93,118.0,299521420,61,61,61,60,%f,%f,50.18,50.64\n" pup_val pdn_val)
drain(out_file)
printf("Result -> pup=%f, pdn=%f (Excel: pup=50.18, pdn=50.64)\n" pup_val pdn_val)

; --- Sim 26/38: TT (tt_res_bip_dio_disres), Vreg=0.95V, Temp=-40.0C, pvtp=29, pvtn=29 ---
printf("\n>>> [BAD] Running TT Sim 26/38: V=0.95V, T=-40.0C, pvtp=29, pvtn=29 <<<\n")
desVar("tem" -40.0)
desVar("vreg" 0.95)
temp(-40.0)
desVar("pvt0" 1)
desVar("pvt1" 0)
desVar("pvt2" 1)
desVar("pvt3" 1)
desVar("pvt4" 1)
desVar("pvt5" 0)
desVar("pvt6" 0)
desVar("pvt7" 0)
desVar("pvt8" 0)
desVar("pvt9" 0)
desVar("pvt10" 0)
desVar("pvt11" 0)
desVar("pvt12" 0)
desVar("pvt13" 0)
desVar("pvtn0" 1)
desVar("pvtn1" 0)
desVar("pvtn2" 1)
desVar("pvtn3" 1)
desVar("pvtn4" 1)
desVar("pvtn5" 0)
desVar("pvtn6" 0)
desVar("pvtn7" 0)
desVar("pvtn8" 0)
desVar("pvtn9" 0)
desVar("pvtn10" 0)
desVar("pvtn11" 0)
desVar("pvtn12" 0)
desVar("pvtn13" 0)
run()
selectResults('tran)
pup_val = average((clip((v("/vdd" ?result "tran") - v("/outn" ?result "tran")) 2e-07 2.5e-07) / clip(i("/xdrv_p/out" ?result "tran") 2e-07 2.5e-07)))
pdn_val = (average((clip(v("/outp" ?result "tran") 2e-07 2.5e-07) / clip(i("/xdrv_p/out" ?result "tran") 2e-07 2.5e-07))) * -1)
fprintf(out_file "TT,TT,tt_res_bip_dio_disres,0.95,-40.0,360920620,29,29,61,61,%f,%f,50.47,49.59\n" pup_val pdn_val)
drain(out_file)
printf("Result -> pup=%f, pdn=%f (Excel: pup=50.47, pdn=49.59)\n" pup_val pdn_val)

; --- Sim 27/38: TT (tt_res_bip_dio_disres), Vreg=0.95V, Temp=-30.5C, pvtp=30, pvtn=30 ---
printf("\n>>> [BAD] Running TT Sim 27/38: V=0.95V, T=-30.5C, pvtp=30, pvtn=30 <<<\n")
desVar("tem" -30.5)
desVar("vreg" 0.95)
temp(-30.5)
desVar("pvt0" 0)
desVar("pvt1" 1)
desVar("pvt2" 1)
desVar("pvt3" 1)
desVar("pvt4" 1)
desVar("pvt5" 0)
desVar("pvt6" 0)
desVar("pvt7" 0)
desVar("pvt8" 0)
desVar("pvt9" 0)
desVar("pvt10" 0)
desVar("pvt11" 0)
desVar("pvt12" 0)
desVar("pvt13" 0)
desVar("pvtn0" 0)
desVar("pvtn1" 1)
desVar("pvtn2" 1)
desVar("pvtn3" 1)
desVar("pvtn4" 1)
desVar("pvtn5" 0)
desVar("pvtn6" 0)
desVar("pvtn7" 0)
desVar("pvtn8" 0)
desVar("pvtn9" 0)
desVar("pvtn10" 0)
desVar("pvtn11" 0)
desVar("pvtn12" 0)
desVar("pvtn13" 0)
run()
selectResults('tran)
pup_val = average((clip((v("/vdd" ?result "tran") - v("/outn" ?result "tran")) 2e-07 2.5e-07) / clip(i("/xdrv_p/out" ?result "tran") 2e-07 2.5e-07)))
pdn_val = (average((clip(v("/outp" ?result "tran") 2e-07 2.5e-07) / clip(i("/xdrv_p/out" ?result "tran") 2e-07 2.5e-07))) * -1)
fprintf(out_file "TT,TT,tt_res_bip_dio_disres,0.95,-30.5,355867860,30,30,29,30,%f,%f,50.69,49.44\n" pup_val pdn_val)
drain(out_file)
printf("Result -> pup=%f, pdn=%f (Excel: pup=50.69, pdn=49.44)\n" pup_val pdn_val)

; --- Sim 28/38: TT (tt_res_bip_dio_disres), Vreg=0.95V, Temp=-20.0C, pvtp=122, pvtn=30 ---
printf("\n>>> [BAD] Running TT Sim 28/38: V=0.95V, T=-20.0C, pvtp=122, pvtn=30 <<<\n")
desVar("tem" -20.0)
desVar("vreg" 0.95)
temp(-20.0)
desVar("pvt0" 0)
desVar("pvt1" 1)
desVar("pvt2" 0)
desVar("pvt3" 1)
desVar("pvt4" 1)
desVar("pvt5" 1)
desVar("pvt6" 1)
desVar("pvt7" 0)
desVar("pvt8" 0)
desVar("pvt9" 0)
desVar("pvt10" 0)
desVar("pvt11" 0)
desVar("pvt12" 0)
desVar("pvt13" 0)
desVar("pvtn0" 0)
desVar("pvtn1" 1)
desVar("pvtn2" 1)
desVar("pvtn3" 1)
desVar("pvtn4" 1)
desVar("pvtn5" 0)
desVar("pvtn6" 0)
desVar("pvtn7" 0)
desVar("pvtn8" 0)
desVar("pvtn9" 0)
desVar("pvtn10" 0)
desVar("pvtn11" 0)
desVar("pvtn12" 0)
desVar("pvtn13" 0)
run()
selectResults('tran)
pup_val = average((clip((v("/vdd" ?result "tran") - v("/outn" ?result "tran")) 2e-07 2.5e-07) / clip(i("/xdrv_p/out" ?result "tran") 2e-07 2.5e-07)))
pdn_val = (average((clip(v("/outp" ?result "tran") 2e-07 2.5e-07) / clip(i("/xdrv_p/out" ?result "tran") 2e-07 2.5e-07))) * -1)
fprintf(out_file "TT,TT,tt_res_bip_dio_disres,0.95,-20.0,350769280,122,30,30,30,%f,%f,49.66,49.7\n" pup_val pdn_val)
drain(out_file)
printf("Result -> pup=%f, pdn=%f (Excel: pup=49.66, pdn=49.7)\n" pup_val pdn_val)

; --- Sim 29/38: TT (tt_res_bip_dio_disres), Vreg=0.95V, Temp=-19.5C, pvtp=122, pvtn=30 ---
printf("\n>>> [BAD] Running TT Sim 29/38: V=0.95V, T=-19.5C, pvtp=122, pvtn=30 <<<\n")
desVar("tem" -19.5)
desVar("vreg" 0.95)
temp(-19.5)
desVar("pvt0" 0)
desVar("pvt1" 1)
desVar("pvt2" 0)
desVar("pvt3" 1)
desVar("pvt4" 1)
desVar("pvt5" 1)
desVar("pvt6" 1)
desVar("pvt7" 0)
desVar("pvt8" 0)
desVar("pvt9" 0)
desVar("pvt10" 0)
desVar("pvt11" 0)
desVar("pvt12" 0)
desVar("pvt13" 0)
desVar("pvtn0" 0)
desVar("pvtn1" 1)
desVar("pvtn2" 1)
desVar("pvtn3" 1)
desVar("pvtn4" 1)
desVar("pvtn5" 0)
desVar("pvtn6" 0)
desVar("pvtn7" 0)
desVar("pvtn8" 0)
desVar("pvtn9" 0)
desVar("pvtn10" 0)
desVar("pvtn11" 0)
desVar("pvtn12" 0)
desVar("pvtn13" 0)
run()
selectResults('tran)
pup_val = average((clip((v("/vdd" ?result "tran") - v("/outn" ?result "tran")) 2e-07 2.5e-07) / clip(i("/xdrv_p/out" ?result "tran") 2e-07 2.5e-07)))
pdn_val = (average((clip(v("/outp" ?result "tran") 2e-07 2.5e-07) / clip(i("/xdrv_p/out" ?result "tran") 2e-07 2.5e-07))) * -1)
fprintf(out_file "TT,TT,tt_res_bip_dio_disres,0.95,-19.5,350518830,122,30,30,30,%f,%f,49.68,49.72\n" pup_val pdn_val)
drain(out_file)
printf("Result -> pup=%f, pdn=%f (Excel: pup=49.68, pdn=49.72)\n" pup_val pdn_val)

; --- Sim 30/38: TT (tt_res_bip_dio_disres), Vreg=0.95V, Temp=19.5C, pvtp=31, pvtn=124 ---
printf("\n>>> [BAD] Running TT Sim 30/38: V=0.95V, T=19.5C, pvtp=31, pvtn=124 <<<\n")
desVar("tem" 19.5)
desVar("vreg" 0.95)
temp(19.5)
desVar("pvt0" 1)
desVar("pvt1" 1)
desVar("pvt2" 1)
desVar("pvt3" 1)
desVar("pvt4" 1)
desVar("pvt5" 0)
desVar("pvt6" 0)
desVar("pvt7" 0)
desVar("pvt8" 0)
desVar("pvt9" 0)
desVar("pvt10" 0)
desVar("pvt11" 0)
desVar("pvt12" 0)
desVar("pvt13" 0)
desVar("pvtn0" 0)
desVar("pvtn1" 0)
desVar("pvtn2" 1)
desVar("pvtn3" 1)
desVar("pvtn4" 1)
desVar("pvtn5" 1)
desVar("pvtn6" 1)
desVar("pvtn7" 0)
desVar("pvtn8" 0)
desVar("pvtn9" 0)
desVar("pvtn10" 0)
desVar("pvtn11" 0)
desVar("pvtn12" 0)
desVar("pvtn13" 0)
run()
selectResults('tran)
pup_val = average((clip((v("/vdd" ?result "tran") - v("/outn" ?result "tran")) 2e-07 2.5e-07) / clip(i("/xdrv_p/out" ?result "tran") 2e-07 2.5e-07)))
pdn_val = (average((clip(v("/outp" ?result "tran") 2e-07 2.5e-07) / clip(i("/xdrv_p/out" ?result "tran") 2e-07 2.5e-07))) * -1)
fprintf(out_file "TT,TT,tt_res_bip_dio_disres,0.95,19.5,334688510,31,124,31,30,%f,%f,49.45,50.66\n" pup_val pdn_val)
drain(out_file)
printf("Result -> pup=%f, pdn=%f (Excel: pup=49.45, pdn=50.66)\n" pup_val pdn_val)

; --- Sim 31/38: TT (tt_res_bip_dio_disres), Vreg=0.95V, Temp=20.0C, pvtp=31, pvtn=31 ---
printf("\n>>> [BAD] Running TT Sim 31/38: V=0.95V, T=20.0C, pvtp=31, pvtn=31 <<<\n")
desVar("tem" 20.0)
desVar("vreg" 0.95)
temp(20.0)
desVar("pvt0" 1)
desVar("pvt1" 1)
desVar("pvt2" 1)
desVar("pvt3" 1)
desVar("pvt4" 1)
desVar("pvt5" 0)
desVar("pvt6" 0)
desVar("pvt7" 0)
desVar("pvt8" 0)
desVar("pvt9" 0)
desVar("pvt10" 0)
desVar("pvt11" 0)
desVar("pvt12" 0)
desVar("pvt13" 0)
desVar("pvtn0" 1)
desVar("pvtn1" 1)
desVar("pvtn2" 1)
desVar("pvtn3" 1)
desVar("pvtn4" 1)
desVar("pvtn5" 0)
desVar("pvtn6" 0)
desVar("pvtn7" 0)
desVar("pvtn8" 0)
desVar("pvtn9" 0)
desVar("pvtn10" 0)
desVar("pvtn11" 0)
desVar("pvtn12" 0)
desVar("pvtn13" 0)
run()
selectResults('tran)
pup_val = average((clip((v("/vdd" ?result "tran") - v("/outn" ?result "tran")) 2e-07 2.5e-07) / clip(i("/xdrv_p/out" ?result "tran") 2e-07 2.5e-07)))
pdn_val = (average((clip(v("/outp" ?result "tran") 2e-07 2.5e-07) / clip(i("/xdrv_p/out" ?result "tran") 2e-07 2.5e-07))) * -1)
fprintf(out_file "TT,TT,tt_res_bip_dio_disres,0.95,20.0,334494080,31,31,31,30,%f,%f,49.46,50.67\n" pup_val pdn_val)
drain(out_file)
printf("Result -> pup=%f, pdn=%f (Excel: pup=49.46, pdn=50.67)\n" pup_val pdn_val)

; --- Sim 32/38: TT (tt_res_bip_dio_disres), Vreg=0.95V, Temp=65.0C, pvtp=31, pvtn=31 ---
printf("\n>>> [BAD] Running TT Sim 32/38: V=0.95V, T=65.0C, pvtp=31, pvtn=31 <<<\n")
desVar("tem" 65.0)
desVar("vreg" 0.95)
temp(65.0)
desVar("pvt0" 1)
desVar("pvt1" 1)
desVar("pvt2" 1)
desVar("pvt3" 1)
desVar("pvt4" 1)
desVar("pvt5" 0)
desVar("pvt6" 0)
desVar("pvt7" 0)
desVar("pvt8" 0)
desVar("pvt9" 0)
desVar("pvt10" 0)
desVar("pvt11" 0)
desVar("pvt12" 0)
desVar("pvt13" 0)
desVar("pvtn0" 1)
desVar("pvtn1" 1)
desVar("pvtn2" 1)
desVar("pvtn3" 1)
desVar("pvtn4" 1)
desVar("pvtn5" 0)
desVar("pvtn6" 0)
desVar("pvtn7" 0)
desVar("pvtn8" 0)
desVar("pvtn9" 0)
desVar("pvtn10" 0)
desVar("pvtn11" 0)
desVar("pvtn12" 0)
desVar("pvtn13" 0)
run()
selectResults('tran)
pup_val = average((clip((v("/vdd" ?result "tran") - v("/outn" ?result "tran")) 2e-07 2.5e-07) / clip(i("/xdrv_p/out" ?result "tran") 2e-07 2.5e-07)))
pdn_val = (average((clip(v("/outp" ?result "tran") 2e-07 2.5e-07) / clip(i("/xdrv_p/out" ?result "tran") 2e-07 2.5e-07))) * -1)
fprintf(out_file "TT,TT,tt_res_bip_dio_disres,0.95,65.0,320876590,31,31,60,31,%f,%f,49.49,50.43\n" pup_val pdn_val)
drain(out_file)
printf("Result -> pup=%f, pdn=%f (Excel: pup=49.49, pdn=50.43)\n" pup_val pdn_val)

; --- Sim 33/38: TT (tt_res_bip_dio_disres), Vreg=0.97V, Temp=-7.5C, pvtp=30, pvtn=123 ---
printf("\n>>> [BAD] Running TT Sim 33/38: V=0.97V, T=-7.5C, pvtp=30, pvtn=123 <<<\n")
desVar("tem" -7.5)
desVar("vreg" 0.97)
temp(-7.5)
desVar("pvt0" 0)
desVar("pvt1" 1)
desVar("pvt2" 1)
desVar("pvt3" 1)
desVar("pvt4" 1)
desVar("pvt5" 0)
desVar("pvt6" 0)
desVar("pvt7" 0)
desVar("pvt8" 0)
desVar("pvt9" 0)
desVar("pvt10" 0)
desVar("pvt11" 0)
desVar("pvt12" 0)
desVar("pvt13" 0)
desVar("pvtn0" 1)
desVar("pvtn1" 1)
desVar("pvtn2" 0)
desVar("pvtn3" 1)
desVar("pvtn4" 1)
desVar("pvtn5" 1)
desVar("pvtn6" 1)
desVar("pvtn7" 0)
desVar("pvtn8" 0)
desVar("pvtn9" 0)
desVar("pvtn10" 0)
desVar("pvtn11" 0)
desVar("pvtn12" 0)
desVar("pvtn13" 0)
run()
selectResults('tran)
pup_val = average((clip((v("/vdd" ?result "tran") - v("/outn" ?result "tran")) 2e-07 2.5e-07) / clip(i("/xdrv_p/out" ?result "tran") 2e-07 2.5e-07)))
pdn_val = (average((clip(v("/outp" ?result "tran") 2e-07 2.5e-07) / clip(i("/xdrv_p/out" ?result "tran") 2e-07 2.5e-07))) * -1)
fprintf(out_file "TT,TT,tt_res_bip_dio_disres,0.97,-7.5,358449280,30,123,30,30,%f,%f,49.83,49.87\n" pup_val pdn_val)
drain(out_file)
printf("Result -> pup=%f, pdn=%f (Excel: pup=49.83, pdn=49.87)\n" pup_val pdn_val)

; --- Sim 34/38: TT (tt_res_bip_dio_disres), Vreg=0.97V, Temp=-5.0C, pvtp=30, pvtn=123 ---
printf("\n>>> [BAD] Running TT Sim 34/38: V=0.97V, T=-5.0C, pvtp=30, pvtn=123 <<<\n")
desVar("tem" -5.0)
desVar("vreg" 0.97)
temp(-5.0)
desVar("pvt0" 0)
desVar("pvt1" 1)
desVar("pvt2" 1)
desVar("pvt3" 1)
desVar("pvt4" 1)
desVar("pvt5" 0)
desVar("pvt6" 0)
desVar("pvt7" 0)
desVar("pvt8" 0)
desVar("pvt9" 0)
desVar("pvt10" 0)
desVar("pvt11" 0)
desVar("pvt12" 0)
desVar("pvt13" 0)
desVar("pvtn0" 1)
desVar("pvtn1" 1)
desVar("pvtn2" 0)
desVar("pvtn3" 1)
desVar("pvtn4" 1)
desVar("pvtn5" 1)
desVar("pvtn6" 1)
desVar("pvtn7" 0)
desVar("pvtn8" 0)
desVar("pvtn9" 0)
desVar("pvtn10" 0)
desVar("pvtn11" 0)
desVar("pvtn12" 0)
desVar("pvtn13" 0)
run()
selectResults('tran)
pup_val = average((clip((v("/vdd" ?result "tran") - v("/outn" ?result "tran")) 2e-07 2.5e-07) / clip(i("/xdrv_p/out" ?result "tran") 2e-07 2.5e-07)))
pdn_val = (average((clip(v("/outp" ?result "tran") 2e-07 2.5e-07) / clip(i("/xdrv_p/out" ?result "tran") 2e-07 2.5e-07))) * -1)
fprintf(out_file "TT,TT,tt_res_bip_dio_disres,0.97,-5.0,357288710,30,123,30,30,%f,%f,49.89,49.93\n" pup_val pdn_val)
drain(out_file)
printf("Result -> pup=%f, pdn=%f (Excel: pup=49.89, pdn=49.93)\n" pup_val pdn_val)

; --- Sim 35/38: TT (tt_res_bip_dio_disres), Vreg=0.97V, Temp=83.5C, pvtp=60, pvtn=60 ---
printf("\n>>> [BAD] Running TT Sim 35/38: V=0.97V, T=83.5C, pvtp=60, pvtn=60 <<<\n")
desVar("tem" 83.5)
desVar("vreg" 0.97)
temp(83.5)
desVar("pvt0" 0)
desVar("pvt1" 0)
desVar("pvt2" 1)
desVar("pvt3" 1)
desVar("pvt4" 1)
desVar("pvt5" 1)
desVar("pvt6" 0)
desVar("pvt7" 0)
desVar("pvt8" 0)
desVar("pvt9" 0)
desVar("pvt10" 0)
desVar("pvt11" 0)
desVar("pvt12" 0)
desVar("pvt13" 0)
desVar("pvtn0" 0)
desVar("pvtn1" 0)
desVar("pvtn2" 1)
desVar("pvtn3" 1)
desVar("pvtn4" 1)
desVar("pvtn5" 1)
desVar("pvtn6" 0)
desVar("pvtn7" 0)
desVar("pvtn8" 0)
desVar("pvtn9" 0)
desVar("pvtn10" 0)
desVar("pvtn11" 0)
desVar("pvtn12" 0)
desVar("pvtn13" 0)
run()
selectResults('tran)
pup_val = average((clip((v("/vdd" ?result "tran") - v("/outn" ?result "tran")) 2e-07 2.5e-07) / clip(i("/xdrv_p/out" ?result "tran") 2e-07 2.5e-07)))
pdn_val = (average((clip(v("/outp" ?result "tran") 2e-07 2.5e-07) / clip(i("/xdrv_p/out" ?result "tran") 2e-07 2.5e-07))) * -1)
fprintf(out_file "TT,TT,tt_res_bip_dio_disres,0.97,83.5,326529150,60,60,60,31,%f,%f,49.88,50.69\n" pup_val pdn_val)
drain(out_file)
printf("Result -> pup=%f, pdn=%f (Excel: pup=49.88, pdn=50.69)\n" pup_val pdn_val)

; --- Sim 36/38: TT (tt_res_bip_dio_disres), Vreg=0.99V, Temp=29.0C, pvtp=30, pvtn=123 ---
printf("\n>>> [BAD] Running TT Sim 36/38: V=0.99V, T=29.0C, pvtp=30, pvtn=123 <<<\n")
desVar("tem" 29.0)
desVar("vreg" 0.99)
temp(29.0)
desVar("pvt0" 0)
desVar("pvt1" 1)
desVar("pvt2" 1)
desVar("pvt3" 1)
desVar("pvt4" 1)
desVar("pvt5" 0)
desVar("pvt6" 0)
desVar("pvt7" 0)
desVar("pvt8" 0)
desVar("pvt9" 0)
desVar("pvt10" 0)
desVar("pvt11" 0)
desVar("pvt12" 0)
desVar("pvt13" 0)
desVar("pvtn0" 1)
desVar("pvtn1" 1)
desVar("pvtn2" 0)
desVar("pvtn3" 1)
desVar("pvtn4" 1)
desVar("pvtn5" 1)
desVar("pvtn6" 1)
desVar("pvtn7" 0)
desVar("pvtn8" 0)
desVar("pvtn9" 0)
desVar("pvtn10" 0)
desVar("pvtn11" 0)
desVar("pvtn12" 0)
desVar("pvtn13" 0)
run()
selectResults('tran)
pup_val = average((clip((v("/vdd" ?result "tran") - v("/outn" ?result "tran")) 2e-07 2.5e-07) / clip(i("/xdrv_p/out" ?result "tran") 2e-07 2.5e-07)))
pdn_val = (average((clip(v("/outp" ?result "tran") 2e-07 2.5e-07) / clip(i("/xdrv_p/out" ?result "tran") 2e-07 2.5e-07))) * -1)
fprintf(out_file "TT,TT,tt_res_bip_dio_disres,0.99,29.0,354988510,30,123,30,30,%f,%f,50.65,50.6\n" pup_val pdn_val)
drain(out_file)
printf("Result -> pup=%f, pdn=%f (Excel: pup=50.65, pdn=50.6)\n" pup_val pdn_val)

; --- Sim 37/38: TT (tt_res_bip_dio_disres), Vreg=0.99V, Temp=30.5C, pvtp=125, pvtn=30 ---
printf("\n>>> [BAD] Running TT Sim 37/38: V=0.99V, T=30.5C, pvtp=125, pvtn=30 <<<\n")
desVar("tem" 30.5)
desVar("vreg" 0.99)
temp(30.5)
desVar("pvt0" 1)
desVar("pvt1" 0)
desVar("pvt2" 1)
desVar("pvt3" 1)
desVar("pvt4" 1)
desVar("pvt5" 1)
desVar("pvt6" 1)
desVar("pvt7" 0)
desVar("pvt8" 0)
desVar("pvt9" 0)
desVar("pvt10" 0)
desVar("pvt11" 0)
desVar("pvt12" 0)
desVar("pvt13" 0)
desVar("pvtn0" 0)
desVar("pvtn1" 1)
desVar("pvtn2" 1)
desVar("pvtn3" 1)
desVar("pvtn4" 1)
desVar("pvtn5" 0)
desVar("pvtn6" 0)
desVar("pvtn7" 0)
desVar("pvtn8" 0)
desVar("pvtn9" 0)
desVar("pvtn10" 0)
desVar("pvtn11" 0)
desVar("pvtn12" 0)
desVar("pvtn13" 0)
run()
selectResults('tran)
pup_val = average((clip((v("/vdd" ?result "tran") - v("/outn" ?result "tran")) 2e-07 2.5e-07) / clip(i("/xdrv_p/out" ?result "tran") 2e-07 2.5e-07)))
pdn_val = (average((clip(v("/outp" ?result "tran") 2e-07 2.5e-07) / clip(i("/xdrv_p/out" ?result "tran") 2e-07 2.5e-07))) * -1)
fprintf(out_file "TT,TT,tt_res_bip_dio_disres,0.99,30.5,354395760,125,30,30,30,%f,%f,50.69,50.64\n" pup_val pdn_val)
drain(out_file)
printf("Result -> pup=%f, pdn=%f (Excel: pup=50.69, pdn=50.64)\n" pup_val pdn_val)

; --- Sim 38/38: TT (tt_res_bip_dio_disres), Vreg=0.99V, Temp=100.0C, pvtp=60, pvtn=14 ---
printf("\n>>> [BAD] Running TT Sim 38/38: V=0.99V, T=100.0C, pvtp=60, pvtn=14 <<<\n")
desVar("tem" 100.0)
desVar("vreg" 0.99)
temp(100.0)
desVar("pvt0" 0)
desVar("pvt1" 0)
desVar("pvt2" 1)
desVar("pvt3" 1)
desVar("pvt4" 1)
desVar("pvt5" 1)
desVar("pvt6" 0)
desVar("pvt7" 0)
desVar("pvt8" 0)
desVar("pvt9" 0)
desVar("pvt10" 0)
desVar("pvt11" 0)
desVar("pvt12" 0)
desVar("pvt13" 0)
desVar("pvtn0" 0)
desVar("pvtn1" 1)
desVar("pvtn2" 1)
desVar("pvtn3" 1)
desVar("pvtn4" 0)
desVar("pvtn5" 0)
desVar("pvtn6" 0)
desVar("pvtn7" 0)
desVar("pvtn8" 0)
desVar("pvtn9" 0)
desVar("pvtn10" 0)
desVar("pvtn11" 0)
desVar("pvtn12" 0)
desVar("pvtn13" 0)
run()
selectResults('tran)
pup_val = average((clip((v("/vdd" ?result "tran") - v("/outn" ?result "tran")) 2e-07 2.5e-07) / clip(i("/xdrv_p/out" ?result "tran") 2e-07 2.5e-07)))
pdn_val = (average((clip(v("/outp" ?result "tran") 2e-07 2.5e-07) / clip(i("/xdrv_p/out" ?result "tran") 2e-07 2.5e-07))) * -1)
fprintf(out_file "TT,TT,tt_res_bip_dio_disres,0.99,100.0,331965890,60,14,60,60,%f,%f,50.25,49.83\n" pup_val pdn_val)
drain(out_file)
printf("Result -> pup=%f, pdn=%f (Excel: pup=50.25, pdn=49.83)\n" pup_val pdn_val)

close(out_file)
printf("\n=== BAD TT Complete! Results in results_bad_TT.csv ===\n")
exit()
