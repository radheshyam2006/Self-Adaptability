// Generated for: spectre
// Generated on: Aug 20 00:07:17 2024
// Design library name: script_run
// Design cell name: OpAmp_INput_offset
// Design view name: schematic
simulator lang=spectre
global 0
parameters wcm1=5u ws=8u id=20u \
    Vx=0
//include "/data/cad/pdk_all/pdk_tsmc/pdk_tsmc_180/tsmc18/../models/spectre/cr018gpii_v1d0.scs" section=tt
//include "/data/cad/pdk_all/pdk_tsmc/pdk_tsmc_180/tsmc18/../models/spectre/cr018gpii_v1d0.scs" section=tt_res
include "/data/cad/pdk_all/pdk_tsmc/pdk_tsmc_180/tsmc18/../models/spectre/cr018gpii_v1d0.scs" section=stat_noise
include "../netlist"
simulatorOptions options psfversion="1.1.0" reltol=1e-3 vabstol=1e-6 \
    iabstol=1e-12 temp=tmp_param tnom=27 scalem=1.0 scale=1.0 gmin=1e-12 rforce=1 \
    maxnotes=5 maxwarns=5 digits=5 cols=80 pivrel=1e-3 \
    sensfile="../psf/sens.output" checklimitdest=psf
dcOp dc write="spectre.dc" maxiters=150 maxsteps=10000 annotate=status
dcOpInfo info what=oppoint where=rawfile
dc dc param=Vx start=-5m stop=5m oppoint=rawfile maxiters=150 \
    maxsteps=10000 annotate=status
modelParameter info what=models where=rawfile
element info what=inst where=rawfile
outputParameter info what=output where=rawfile
designParamVals info what=parameters where=rawfile
primitives info what=primitives where=rawfile
subckts info what=subckts where=rawfile
saveOptions options save=allpub
